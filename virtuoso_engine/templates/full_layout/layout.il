; ============================================================
; FULL LAYOUT — AUTO-GENERATED SCRIPT
; Generated by VirtuosoPixelEngine from templates/full_layout/layout.il
; Do not edit by hand.
;
; Pixel types placed as real cells:
;   0 — ground fill only (gnd_layer rectangle)
;   1 — metal patch (pixel_layer) + ground fill
;   2 — inductor cell duplicated from library (placeholder until cell provided)
;   3 — switch cell built from NMOS + MIM cap (derived from layout_pixel)
;   4 — via stack from gnd_layer to pixel_layer (grounds the pixel)
;
; Coordinate system (same as pixelated_design_simple):
;   Origin at lower-left of pixel grid.
;   col increases right (+x), row 0 is top → y-flipped.
;   pixel_center_x(col) = col * grid_size + grid_size/2
;   pixel_center_y(row) = (num_rows - 1 - row) * grid_size + grid_size/2
; ============================================================

; ============================================================
; SECTION 1 — USER CONFIGURATION  (filled in by Python engine)
; ============================================================

procedure( build_full_layout()
let( ( cv libName cellName
       pixel_size grid_size
       gnd_layer pixel_layer
       switch_drain_via_bot switch_drain_via_top
       switch_bulk_via_bot  switch_bulk_via_top
       switch_mim_via_bot   switch_mim_via_top
       cap_pair_route_layer
       via_pixel_stack_bot  via_pixel_stack_top
       num_rows num_cols
       pixel_types
       switch_cap_dims
       nmos_width nmos_length nmos_fingers
       pdk_lib nmos_cell mim_cell_layout
       inductor_lib inductor_cell
       inductor_offset_x inductor_offset_y
       cap_pair_count cap_pair_pixels cap_pair_dims cap_pair_orient
       cap_pair_wire_width
       via_size
       feedline_row_left feedline_row_right feedline_width feedline_padding
       gnd_y_extension
       constraint_group_id viaOptions
       fl_left_y_center  fl_left_y_bottom  fl_left_y_top
       fl_right_y_center fl_right_y_bottom fl_right_y_top
       gnd_y_bottom gnd_y_top
       fl_x_left fl_x_right
       pin_size feedline_pin_size
       sw_idx ind_idx
       ind_inst_list
     )

libName              = "${LIB_NAME}"
cellName             = "${CELL_NAME}"
pixel_size           = ${PIXEL_SIZE}
grid_size            = ${GRID_SIZE}
gnd_layer            = "${GND_LAYER}"
pixel_layer          = "${PIXEL_LAYER}"
switch_drain_via_bot = "${SWITCH_DRAIN_VIA_BOT}"
switch_drain_via_top = "${SWITCH_DRAIN_VIA_TOP}"
switch_bulk_via_bot  = "${SWITCH_BULK_VIA_BOT}"
switch_bulk_via_top  = "${SWITCH_BULK_VIA_TOP}"
switch_mim_via_bot   = "${SWITCH_MIM_VIA_BOT}"
switch_mim_via_top   = "${SWITCH_MIM_VIA_TOP}"
cap_pair_route_layer = "${CAP_PAIR_ROUTE_LAYER}"
via_pixel_stack_bot  = "${VIA_PIXEL_STACK_BOT}"
via_pixel_stack_top  = "${VIA_PIXEL_STACK_TOP}"
num_rows             = ${NUM_ROWS}
num_cols             = ${NUM_COLS}
pixel_types          = ${PIXEL_TYPES_SKILL}
switch_cap_dims      = ${SWITCH_CAP_DIMS_SKILL}
nmos_width           = "${NMOS_WIDTH}"
nmos_length          = "${NMOS_LENGTH}"
nmos_fingers         = "${NMOS_FINGERS}"
pdk_lib              = "${PDK_LIB}"
nmos_cell            = "${NMOS_CELL}"
mim_cell_layout      = "${MIM_CELL_LAYOUT}"
inductor_lib         = "${INDUCTOR_LIB}"
inductor_cell        = "${INDUCTOR_CELL}"
inductor_offset_x    = ${INDUCTOR_OFFSET_X}
inductor_offset_y    = ${INDUCTOR_OFFSET_Y}
cap_pair_count       = ${CAP_PAIR_COUNT}
cap_pair_pixels      = ${CAP_PAIR_PIXELS_SKILL}
cap_pair_dims        = ${CAP_PAIR_DIMS_SKILL}
cap_pair_orient      = ${CAP_PAIR_ORIENT_SKILL}
cap_pair_wire_width  = ${CAP_PAIR_WIRE_WIDTH}
via_size             = ${VIA_SIZE}
feedline_row_left    = ${FEEDLINE_ROW_LEFT}
feedline_row_right   = ${FEEDLINE_ROW_RIGHT}
feedline_width       = ${FEEDLINE_WIDTH}
feedline_padding     = ${FEEDLINE_PADDING}
gnd_y_extension      = ${GND_Y_EXTENSION}

pin_size         = 0.5
feedline_pin_size = feedline_width

; ============================================================
; SECTION 2 — OPEN CELL VIEW
; ============================================================

cv = dbOpenCellViewByType(libName cellName "layout" "maskLayout" "w")
unless(cv
    let((staleCell)
        staleCell = ddGetObj(libName cellName)
        when(staleCell ddDeleteObj(staleCell))
    )
    cv = dbOpenCellViewByType(libName cellName "layout" "maskLayout" "w")
)
unless(cv
    error("*Error* [FullLayout] Failed to open/create cell view for %s/%s\n"
          libName cellName)
)
printf("--- Generating Full Layout: %s/%s ---\n" libName cellName)

; Shared via options (used by all via generation calls)
constraint_group_id = cstFindConstraintGroupIn(techGetTechFile(cv) "virtuosoDefaultSetup")
viaOptions = viaGetViaOptions(constraint_group_id)
viaOptions~>createInRoute = nil

; ============================================================
; SECTION 3 — FEEDLINE GEOMETRY  (identical to pixelated_design_simple)
; ============================================================

; Feedline rows read from matrix col 0 (left) and col N-1 (right) — same as
; pixelated_design_simple: the single non-zero cell in each feed column marks
; the feedline row.  This means the matrix drives geometry, not a config field.
fl_left_y_center  = (num_rows - 1 - feedline_row_left)  * grid_size + grid_size / 2.0
fl_left_y_bottom  = fl_left_y_center  - feedline_width / 2.0
fl_left_y_top     = fl_left_y_center  + feedline_width / 2.0

fl_right_y_center = (num_rows - 1 - feedline_row_right) * grid_size + grid_size / 2.0
fl_right_y_bottom = fl_right_y_center - feedline_width / 2.0
fl_right_y_top    = fl_right_y_center + feedline_width / 2.0

gnd_y_bottom = 0.0 - gnd_y_extension
gnd_y_top    = num_rows * grid_size + gnd_y_extension

fl_x_left  = 0.0 - feedline_padding
fl_x_right = num_cols * grid_size + feedline_padding

; Left feed column: feedline trace + ground fill
dbCreateRect(cv pixel_layer
    list(list(0.0 fl_left_y_bottom) list(grid_size fl_left_y_top)))
dbCreateRect(cv gnd_layer
    list(list(0.0 gnd_y_bottom) list(grid_size gnd_y_top)))

; Right feed column: feedline trace + ground fill
dbCreateRect(cv pixel_layer
    list(list((num_cols - 1) * grid_size fl_right_y_bottom)
         list(num_cols * grid_size fl_right_y_top)))
dbCreateRect(cv gnd_layer
    list(list((num_cols - 1) * grid_size gnd_y_bottom)
         list(num_cols * grid_size gnd_y_top)))

; Left extension beyond the grid
dbCreateRect(cv pixel_layer
    list(list(fl_x_left fl_left_y_bottom) list(0.0 fl_left_y_top)))
dbCreateRect(cv gnd_layer
    list(list(fl_x_left gnd_y_bottom) list(0.0 gnd_y_top)))

; Right extension beyond the grid
dbCreateRect(cv pixel_layer
    list(list(num_cols * grid_size fl_right_y_bottom) list(fl_x_right fl_right_y_top)))
dbCreateRect(cv gnd_layer
    list(list(num_cols * grid_size gnd_y_bottom) list(fl_x_right gnd_y_top)))

; PIX_IN and PIX_IN_GND (left end)
let( (pin_box)
    pin_box = list(
        list(fl_x_left            fl_left_y_center - feedline_pin_size/2.0)
        list(fl_x_left + pin_size fl_left_y_center + feedline_pin_size/2.0))
    fl_create_pin(cv "PIX_IN"     list(pixel_layer "pin") pin_box "input")
    fl_create_pin(cv "PIX_IN_GND" list(gnd_layer   "pin") pin_box "inputOutput")
)

; PIX_OUT and PIX_OUT_GND (right end)
let( (pin_box)
    pin_box = list(
        list(fl_x_right - pin_size fl_right_y_center - feedline_pin_size/2.0)
        list(fl_x_right            fl_right_y_center + feedline_pin_size/2.0))
    fl_create_pin(cv "PIX_OUT"     list(pixel_layer "pin") pin_box "output")
    fl_create_pin(cv "PIX_OUT_GND" list(gnd_layer   "pin") pin_box "inputOutput")
)

printf(" [3] Feedlines drawn. left_y=%.2f  right_y=%.2f\n"
       fl_left_y_center fl_right_y_center)

; ============================================================
; SECTION 4 — ACTIVE PIXEL GRID  (cols 1 to num_cols-2)
; ============================================================

sw_idx       = 0   ; running index into switch_cap_dims
ind_idx      = 0   ; running index for inductor placement
ind_inst_list = list()  ; collect placed inductor insts for ground carve-out

for( row_i 0 (num_rows - 1)
    for( col_i 1 (num_cols - 2)

        let( (flat_idx ptype cx cy)
            flat_idx = row_i * num_cols + col_i
            ptype    = nth(flat_idx pixel_types)
            cx       = col_i * grid_size + grid_size / 2.0
            cy       = (num_rows - 1 - row_i) * grid_size + grid_size / 2.0

            cond(
                ; --- Type 0: ground fill only ---
                ( ptype == 0
                    dbCreateRect(cv gnd_layer
                        list(list(cx - grid_size/2.0 cy - grid_size/2.0)
                             list(cx + grid_size/2.0 cy + grid_size/2.0)))
                )

                ; --- Type 1: metal patch + ground fill ---
                ( ptype == 1
                    dbCreateRect(cv gnd_layer
                        list(list(cx - grid_size/2.0  cy - grid_size/2.0)
                             list(cx + grid_size/2.0  cy + grid_size/2.0)))
                    dbCreateRect(cv pixel_layer
                        list(list(cx - pixel_size/2.0 cy - pixel_size/2.0)
                             list(cx + pixel_size/2.0 cy + pixel_size/2.0)))
                )

                ; --- Type 2: inductor cell + top metal patch ---
                ( ptype == 2
                    let( (ind_inst)
                        ind_inst = fl_place_inductor_at(cv cx cy inductor_lib inductor_cell ind_idx
                            inductor_offset_x inductor_offset_y)
                        when( ind_inst
                            ind_inst_list = append(ind_inst_list list(ind_inst))
                        )
                    )
                    dbCreateRect(cv pixel_layer
                        list(list(cx - pixel_size/2.0 cy - pixel_size/2.0)
                             list(cx + pixel_size/2.0 cy + pixel_size/2.0)))
                    ind_idx = ind_idx + 1
                )

                ; --- Type 3: switch cell (NMOS + MIM cap) ---
                ( ptype == 3
                    let( (sw_dim mim_l mim_w)
                        sw_dim = nth(sw_idx switch_cap_dims)
                        mim_l  = car(sw_dim)
                        mim_w  = cadr(sw_dim)
                        fl_build_switch_at(cv cx cy mim_l mim_w viaOptions
                            nmos_width nmos_length nmos_fingers
                            pdk_lib nmos_cell mim_cell_layout
                            pixel_size gnd_layer pixel_layer
                            switch_drain_via_bot switch_drain_via_top
                            switch_bulk_via_bot  switch_bulk_via_top
                            switch_mim_via_bot   switch_mim_via_top
                            via_size sw_idx)
                        sw_idx = sw_idx + 1
                    )
                )

                ; --- Type 4: via pixel (ground short) + top metal patch ---
                ( ptype == 4
                    fl_build_via_pixel_at(cv cx cy via_size
                        via_pixel_stack_bot via_pixel_stack_top viaOptions)
                    dbCreateRect(cv pixel_layer
                        list(list(cx - pixel_size/2.0 cy - pixel_size/2.0)
                             list(cx + pixel_size/2.0 cy + pixel_size/2.0)))
                )
            ) ; end cond
        ) ; end let
    ) ; end for col_i
) ; end for row_i

; Ground fill for entire active area (background, under device cells)
for( col_i 1 (num_cols - 2)
    dbCreateRect(cv gnd_layer
        list(list(col_i * grid_size       gnd_y_bottom)
             list((col_i + 1) * grid_size gnd_y_top)))
)

; Carve out inductor bounding boxes from ground layer.
; dbLayerAndNot creates new carved shapes but does NOT delete the originals —
; we must explicitly delete the original shapes and the keepout rect.
when( ind_inst_list
    foreach( ind_inst ind_inst_list
        let( (ind_bbox ko_shape all_gnd)
            ind_bbox = ind_inst~>bBox
            ; Create keepout rect FIRST so we can exclude it from the shape list
            ko_shape = dbCreateRect(cv gnd_layer ind_bbox)
            ; Collect all gnd_layer shapes that are NOT the keepout itself
            all_gnd  = setof(s cv~>shapes
                             (s~>layer == gnd_layer && s != ko_shape))
            when( all_gnd
                ; Creates new carved shapes (originals are NOT auto-deleted)
                dbLayerAndNot(cv gnd_layer all_gnd list(ko_shape))
                ; Delete the un-carved originals
                foreach(s all_gnd dbDeleteObject(s))
            )
            dbDeleteObject(ko_shape)
            printf("  [inductor carve-out] gnd_layer cleared at bBox (%.2f %.2f)→(%.2f %.2f)\n"
                   xCoord(lowerLeft(ind_bbox))  yCoord(lowerLeft(ind_bbox))
                   xCoord(upperRight(ind_bbox)) yCoord(upperRight(ind_bbox)))
        )
    )
)

printf(" [4] Active pixel grid placed: %d rows x %d active cols\n"
       num_rows (num_cols - 2))

; ============================================================
; SECTION 5 — CAP PAIRS
; ============================================================

when( cap_pair_count > 0
    printf(" [5] Placing %d cap pair(s)...\n" cap_pair_count)
    for( cp_i 0 (cap_pair_count - 1)
        let( (cpx r1 c1 r2 c2 cap_l cap_w orient)
            cpx    = nth(cp_i cap_pair_pixels)
            r1     = nth(0 cpx)
            c1     = nth(1 cpx)
            r2     = nth(2 cpx)
            c2     = nth(3 cpx)
            cap_l  = car(nth(cp_i cap_pair_dims))
            cap_w  = cadr(nth(cp_i cap_pair_dims))
            orient = nth(cp_i cap_pair_orient)
            fl_build_cap_pair(cv r1 c1 r2 c2 cap_l cap_w orient
                grid_size num_rows
                pdk_lib mim_cell_layout
                cap_pair_route_layer viaOptions cp_i
                switch_mim_via_bot gnd_layer via_size cap_pair_wire_width)
        )
    )
)

; ============================================================
; SECTION 6 — SAVE AND CLOSE
; ============================================================

dbSave(cv)
dbClose(cv)
printf("--- Full Layout Complete: %s/%s ---\n" libName cellName)

) ; end let
) ; end procedure build_full_layout

; ============================================================
; HELPER: fl_create_pin — create net + term + pin rect + label
; ============================================================

procedure( fl_create_pin(cv netName layerName bbox termDir)
    let( (net term fig)
        net  = dbFindNetByName(cv netName)
        unless(net  net  = dbCreateNet(cv netName))
        term = dbFindTermByName(cv netName)
        unless(term term = dbCreateTerm(net netName termDir))
        fig  = dbCreateRect(cv layerName bbox)
        dbCreatePin(net fig netName)
        dbCreateLabel(cv layerName car(bbox) netName "centerCenter" "R0" "roman" 0.5)
    )
)

; ============================================================
; HELPER: fl_get_pin_boundary — return transformed bBox of a pin
; (same logic as get_pin_boundary in layout_pixel/layout.il)
; ============================================================

procedure( fl_get_pin_boundary(inst pinName)
    let( (master term pin fig rawBBox)
        master = inst~>master
        term   = dbFindTermByName(master pinName)
        if( term then
            pin    = car(term~>pins)
            fig    = car(pin~>figs)
            rawBBox = fig~>bBox
            dbTransformBBox(rawBBox inst~>transform)
        else
            nil
        )
    )
)

; ============================================================
; HELPER: fl_build_switch_at
;   Builds a complete switch pixel (NMOS + MIM cap) centred at (cx, cy).
;   Adapted from templates/layout_pixel/layout.il.
;   All layer names are passed as parameters — no hardcoded layers.
; ============================================================

procedure( fl_build_switch_at(cv cx cy mim_l mim_w viaOptions
                               nmos_w nmos_l nmos_f
                               pdk_lib nmos_cell mim_cell
                               pixel_size gnd_layer pixel_layer
                               drain_via_bot drain_via_top
                               bulk_via_bot  bulk_via_top
                               mim_via_bot   mim_via_top
                               via_size sw_idx)
let( ( nmos_master nmos_inst mim_master mim_inst
       nmos_name mim_name
       drain_box gate_box bulk_label_box
       mim_plus_box mim_minus_box mim_bulk_box
       x_center y_bottom target_point
       dx dy
       half_size p1 p2 p3 p4 area_polygon keepout_box
       pixel_center_y pixel_box
       keepout_expanded spacing
     )

printf("  [switch] Placing switch at (%.2f, %.2f)  mim_l=%s mim_w=%s\n"
       cx cy mim_l mim_w)

; --- Place NMOS at origin first, then shift so pixel patch centre = (cx, cy) ---
; This is the same pin-alignment trick used for the MIM cap: place at (0,0),
; query the drain pin to predict where the pixel patch will land, compute dx/dy
; to align that predicted centre with the target (cx, cy), then move the instance.
nmos_master = dbOpenCellViewByType(pdk_lib nmos_cell "layout")
if( !nmos_master then error("[fl_build_switch_at] NMOS master not found: %s/%s" pdk_lib nmos_cell))

nmos_name = sprintf(nil "M%d" sw_idx)
nmos_inst = dbCreateParamInst(cv nmos_master nmos_name list(0.0 0.0) "R0" 1
    list(list("wr" "string" nmos_w)
         list("lr" "string" nmos_l)
         list("nr" "string" nmos_f)))

; Query drain pin at (0,0) placement to compute pixel-patch centre offset
let( (d_box_local x_drain_local y_drain_local target_y_local
      pixel_local_x pixel_local_y dx_nmos dy_nmos)
    d_box_local    = fl_get_pin_boundary(nmos_inst "D")
    when( d_box_local
        x_drain_local  = (xCoord(lowerLeft(d_box_local)) + xCoord(upperRight(d_box_local))) / 2.0
        y_drain_local  = yCoord(lowerLeft(d_box_local))
        target_y_local = y_drain_local - 2.0
        ; Pixel patch centre formula (from layout_pixel):
        ;   pixel_center_y = target_y - via_size + pixel_size/2 - 2
        pixel_local_x  = x_drain_local
        pixel_local_y  = target_y_local - via_size + pixel_size / 2.0 - 2.0
        ; Shift NMOS so pixel patch centre lands on (cx, cy)
        dx_nmos = cx - pixel_local_x
        dy_nmos = cy - pixel_local_y
        nmos_inst~>xy = list(dx_nmos dy_nmos)
    )
)

; --- Drain: extend path downward then build via stack ---
; Re-query drain pin after the instance has been moved to its final position.
drain_box = fl_get_pin_boundary(nmos_inst "D")
if( drain_box then
    x_center     = (xCoord(lowerLeft(drain_box)) + xCoord(upperRight(drain_box))) / 2.0
    y_bottom     = yCoord(lowerLeft(drain_box))
    target_point = list(x_center (y_bottom - 2.0))

    dbCreatePath(cv drain_via_bot list(list(x_center y_bottom) target_point) 0.5)

    let( (vx vy)
        vx = xCoord(target_point)
        vy = yCoord(target_point)
        half_size   = via_size / 2.0
        p1 = list(vx - half_size vy - 2 * half_size)
        p2 = list(vx + half_size vy - 2 * half_size)
        p3 = list(vx + half_size vy)
        p4 = list(vx - half_size vy)
        area_polygon = list(p1 p2 p3 p4)
        keepout_box  = list(p1 p3)
        dbCreatePolygon(cv drain_via_bot area_polygon)
        dbCreatePolygon(cv drain_via_top area_polygon)
        viaGenerateViasInArea(cv area_polygon viaOptions
            ?topAndBottomLayers list(drain_via_bot drain_via_top))
    )

    ; --- Gate pin extension ---
    gate_box = fl_get_pin_boundary(nmos_inst "G")
    when( gate_box
        let( (g_cx g_top)
            g_cx  = (xCoord(lowerLeft(gate_box)) + xCoord(upperRight(gate_box))) / 2.0
            g_top = yCoord(upperRight(gate_box))
            dbCreatePath(cv "M3" list(list(g_cx g_top) list(g_cx g_top + 1.0)) 0.5)
        )
    )

    ; --- Bulk connection via (bulk_via_bot → bulk_via_top) ---
    bulk_label_box = fl_get_pin_boundary(nmos_inst "B")
    when( bulk_label_box
        let( (b_left b_bot b_top patch_width patch_poly via_region)
            b_left      = xCoord(lowerLeft(bulk_label_box)) + 0.1
            b_bot       = yCoord(lowerLeft(bulk_label_box))
            b_top       = yCoord(upperRight(bulk_label_box))
            patch_width = 0.6
            patch_poly  = list(
                list(b_left               b_bot)
                list(b_left + patch_width b_bot)
                list(b_left + patch_width b_top)
                list(b_left               b_top))
            via_region  = list(
                list(b_left + 0.15        b_bot)
                list(b_left + 0.15 + 0.5  b_bot)
                list(b_left + 0.15 + 0.5  b_top)
                list(b_left + 0.15        b_top))
            dbCreatePolygon(cv bulk_via_bot patch_poly)
            dbCreatePolygon(cv bulk_via_top patch_poly)
            viaGenerateViasInArea(cv via_region viaOptions
                ?topAndBottomLayers list(bulk_via_bot bulk_via_top))
        )
    )

    ; --- Place MIM cap: align PLUS pin to target_point ---
    mim_master = dbOpenCellViewByType(pdk_lib mim_cell "layout")
    when( mim_master
        mim_name = sprintf(nil "C%d" sw_idx)
        mim_inst = dbCreateParamInst(cv mim_master mim_name list(0.0 0.0) "R90" 1
            list(list("lt" "string" mim_l)
                 list("wt" "string" mim_w)))

        mim_plus_box = fl_get_pin_boundary(mim_inst "PLUS")
        when( mim_plus_box
            let( (pin_cx pin_bottom_y)
                ; Move instance so PLUS pin aligns to target_point
                pin_cx       = (xCoord(lowerLeft(mim_plus_box)) + xCoord(upperRight(mim_plus_box))) / 2.0
                pin_bottom_y = yCoord(lowerLeft(mim_plus_box))
                dx = xCoord(target_point) - pin_cx
                dy = yCoord(target_point) - pin_bottom_y
                mim_inst~>xy = list(dx dy)
                ; Re-query pins after move
                mim_plus_box  = fl_get_pin_boundary(mim_inst "PLUS")
                mim_minus_box = fl_get_pin_boundary(mim_inst "MINUS")
                mim_bulk_box  = fl_get_pin_boundary(mim_inst "BULK")
            )
        )

        ; MINUS side: via from mim_via_bot to mim_via_top → exposes top-metal patch
        when( mim_minus_box
            let( (mx my m_half_width m_poly)
                mx          = (xCoord(lowerLeft(mim_minus_box)) + xCoord(upperRight(mim_minus_box))) / 2.0
                my          = yCoord(upperRight(mim_minus_box))
                m_half_width = 1.0
                m_poly = list(
                    list(mx - m_half_width my)
                    list(mx + m_half_width my)
                    list(mx + m_half_width my + 2 * m_half_width)
                    list(mx - m_half_width my + 2 * m_half_width))
                dbCreatePolygon(cv mim_via_bot m_poly)
                dbCreatePolygon(cv mim_via_top m_poly)
                viaGenerateViasInArea(cv m_poly viaOptions
                    ?topAndBottomLayers list(mim_via_bot mim_via_top))
            )
        )

        ; BULK: connect MIM cap bulk (M5) down to gnd_layer (M4)
        when( mim_bulk_box
            let( (x_start y_start w_p h_p m_poly)
                x_start = xCoord(lowerLeft(mim_bulk_box))
                y_start = yCoord(lowerLeft(mim_bulk_box))
                w_p = 1.0  h_p = 2.0
                m_poly = list(
                    list(x_start - w_p y_start)
                    list(x_start       y_start)
                    list(x_start       y_start + h_p)
                    list(x_start - w_p y_start + h_p))
                dbCreatePolygon(cv "M5" m_poly)
                dbCreatePolygon(cv gnd_layer m_poly)
                viaGenerateViasInArea(cv m_poly viaOptions
                    ?topAndBottomLayers list(gnd_layer "M5"))
            )
        )
    ) ; end when mim_master

    ; --- Pixel metal patch centred at target location ---
    pixel_center_y = yCoord(target_point) - via_size + pixel_size/2.0 - 2.0
    pixel_box = list(
        list(xCoord(target_point) - pixel_size/2.0  pixel_center_y - pixel_size/2.0)
        list(xCoord(target_point) + pixel_size/2.0  pixel_center_y + pixel_size/2.0))
    dbCreateRect(cv pixel_layer pixel_box)

    ; Ground fill with keepout around drain via
    spacing          = 1.0
    keepout_expanded = list(
        list(xCoord(lowerLeft(keepout_box))  - spacing yCoord(lowerLeft(keepout_box))  - spacing)
        list(xCoord(upperRight(keepout_box)) + spacing yCoord(upperRight(keepout_box)) + spacing))
    let( (gnd_fig ko_rect)
        gnd_fig  = dbCreateRect(cv gnd_layer pixel_box)
        ko_rect  = dbCreateRect(cv gnd_layer keepout_expanded)
        dbLayerAndNot(cv gnd_layer list(gnd_fig) list(ko_rect))
        dbDeleteObject(gnd_fig)
        dbDeleteObject(ko_rect)
    )

else
    warn("[fl_build_switch_at] Drain pin D not found on NMOS at (%.2f, %.2f)" cx cy)
) ; end if drain_box

) ; end let
) ; end procedure fl_build_switch_at

; ============================================================
; HELPER: fl_place_inductor_at
;   Duplicates an existing inductor cell and positions it at (cx, cy).
;   When inductor_lib / inductor_cell are empty (placeholder), logs a
;   warning and draws a marker rectangle instead.
; ============================================================

procedure( fl_place_inductor_at(cv cx cy ind_lib ind_cell ind_idx offset_x offset_y)
; Place inductor so its IN pin center aligns with pixel center (cx, cy),
; then apply user-defined offset (offset_x, offset_y).
; Same pin-alignment trick as used for NMOS and MIM cap positioning.
; Returns the placed inst (or nil for placeholder) so caller can track bBox for ground carve-out.
    if( (ind_lib != "" && ind_cell != "") then
        let( (master inst ind_name in_box in_cx in_cy dx dy)
            master   = dbOpenCellViewByType(ind_lib ind_cell "layout")
            ind_name = sprintf(nil "IND%d" ind_idx)
            if( master then
                ; Step 1: place at origin so we can query the IN pin location
                inst = dbCreateInst(cv master ind_name list(0.0 0.0) "R0")
                ; Step 2: find IN pin bBox on the master (transformed to world coords)
                in_box = fl_get_pin_boundary(inst "IN")
                if( in_box then
                    in_cx = (xCoord(lowerLeft(in_box)) + xCoord(upperRight(in_box))) / 2.0
                    in_cy = (yCoord(lowerLeft(in_box)) + yCoord(upperRight(in_box))) / 2.0
                    ; Step 3: shift so IN pin centre = (cx, cy) + user offset
                    dx = cx - in_cx + offset_x
                    dy = cy - in_cy + offset_y
                    inst~>xy = list(dx dy)
                    printf("  [inductor] Placed %s/%s  IN-pin aligned to (%.2f, %.2f)  offset=(%.2f, %.2f)\n"
                           ind_lib ind_cell cx cy offset_x offset_y)
                else
                    ; IN pin not found — fall back to placing origin at pixel centre + offset
                    inst~>xy = list(cx + offset_x cy + offset_y)
                    warn("[fl_place_inductor_at] IN pin not found on %s/%s — using origin placement"
                         ind_lib ind_cell)
                )
                inst  ; return inst for bBox tracking
            else
                warn("[fl_place_inductor_at] Inductor master not found: %s/%s" ind_lib ind_cell)
                nil
            )
        )
    else
        ; Placeholder: draw a marker rectangle to show inductor position
        let( (half)
            half = 5.0
            dbCreateRect(cv "M9"
                list(list(cx - half cy - half) list(cx + half cy + half)))
            printf("  [inductor] PLACEHOLDER at (%.2f, %.2f) — set inductor_lib/cell in config\n"
                   cx cy)
        )
        nil  ; no inst to track for placeholder
    )
)

; ============================================================
; HELPER: fl_build_via_pixel_at
;   Creates a solid via stack from via_stack_bot to via_stack_top at (cx, cy).
;   Used for type-4 (ground-short) pixels.
; ============================================================

procedure( fl_build_via_pixel_at(cv cx cy via_size stack_bot stack_top viaOptions)
    let( (half area_poly)
        half = via_size / 2.0
        area_poly = list(
            list(cx - half cy - half)
            list(cx + half cy - half)
            list(cx + half cy + half)
            list(cx - half cy + half))
        dbCreatePolygon(cv stack_bot area_poly)
        dbCreatePolygon(cv stack_top area_poly)
        viaGenerateViasInArea(cv area_poly viaOptions
            ?topAndBottomLayers list(stack_bot stack_top))
        printf("  [via pixel] at (%.2f, %.2f)  %s→%s\n" cx cy stack_bot stack_top)
    )
)

; ============================================================
; HELPER: fl_build_cap_pair
;   Places a MIM capacitor at the midpoint between two pixel centers,
;   then routes cap_metal_layer (M8) paths from each pin to the
;   corresponding pixel center using a 90-degree zigzag, and brings
;   the connection to route_layer (AP) with a via stack.
;   BULK is tied to ground the same way as the switch bulk pin.
;
;   Rotation convention:
;     H (same row)  → R90  (cap perpendicular to horizontal axis)
;     V (same col)  → R0   (cap perpendicular to vertical axis)
;
;   Zigzag routing (same for both orientations):
;     1. Find pin center (plus_cx, plus_cy) / (minus_cx, minus_cy).
;     2. First M8 segment: horizontal from pin to (cx_target, pin_cy).
;     3. Second M8 segment: vertical from corner to (cx_target, cy_target).
;     4. Via polygon at pixel center: cap_metal_layer → route_layer.
; ============================================================

procedure( fl_build_cap_pair(cv r1 c1 r2 c2 cap_l cap_w orient
                              grid_size num_rows
                              pdk_lib mim_cell
                              route_layer viaOptions cp_idx
                              cap_metal_layer gnd_layer via_size wire_width)
let( ( cx1 cy1 cx2 cy2 mx my
       mim_master cap_inst cap_name
       mim_plus_box mim_minus_box mim_bulk_box
       plus_cx plus_cy minus_cx minus_cy
       half_via via_poly
       rot
     )

cx1 = c1 * grid_size + grid_size / 2.0
cy1 = (num_rows - 1 - r1) * grid_size + grid_size / 2.0
cx2 = c2 * grid_size + grid_size / 2.0
cy2 = (num_rows - 1 - r2) * grid_size + grid_size / 2.0

; Cap placed at midpoint between the two pixel centers
mx = (cx1 + cx2) / 2.0
my = (cy1 + cy2) / 2.0

mim_master = dbOpenCellViewByType(pdk_lib mim_cell "layout")
unless(mim_master
    warn("[fl_build_cap_pair] MIM cap master not found: %s/%s" pdk_lib mim_cell)
    return(nil)
)

; H → R90  BULK ends up on the left   (correct for H, extends left  in grounding code)
; V → R180 BULK ends up on the right  (correct for V, extends right in grounding code)
; The two orientations are now exactly 90° apart, matching the perpendicular cap placement.
rot = if( orient == "H" then "R90" else "R180" )

cap_name = sprintf(nil "CP%d" cp_idx)
cap_inst = dbCreateParamInst(cv mim_master cap_name list(mx my) rot 1
    list(list("lt" "string" cap_l)
         list("wt" "string" cap_w)))

half_via   = via_size / 2.0

; --- PLUS pin → pixel1 center (90-degree M8 zigzag + via to AP) ---
; Zigzag direction depends on orientation to avoid zero-length segments:
;   H pair (same row, cx1 ≠ plus_cx): corner at (cx1, plus_cy)  — X-first, then Y
;   V pair (same col, cy1 ≠ plus_cy): corner at (plus_cx, cy1)  — Y-first, then X
; This guarantees both segments are non-zero regardless of where the pin sits.
mim_plus_box = fl_get_pin_boundary(cap_inst "PLUS")
when( mim_plus_box
    plus_cx = (xCoord(lowerLeft(mim_plus_box)) + xCoord(upperRight(mim_plus_box))) / 2.0
    plus_cy = (yCoord(lowerLeft(mim_plus_box)) + yCoord(upperRight(mim_plus_box))) / 2.0
    if( orient == "H" then
        dbCreatePath(cv cap_metal_layer
            list(list(plus_cx plus_cy) list(cx1 plus_cy) list(cx1 cy1))
            wire_width)
    else
        dbCreatePath(cv cap_metal_layer
            list(list(plus_cx plus_cy) list(plus_cx cy1) list(cx1 cy1))
            wire_width)
    )
    ; Via polygon at pixel1 center: cap_metal_layer → route_layer
    via_poly = list(
        list(cx1 - half_via cy1 - half_via)
        list(cx1 + half_via cy1 - half_via)
        list(cx1 + half_via cy1 + half_via)
        list(cx1 - half_via cy1 + half_via))
    dbCreatePolygon(cv cap_metal_layer via_poly)
    dbCreatePolygon(cv route_layer     via_poly)
    viaGenerateViasInArea(cv via_poly viaOptions
        ?topAndBottomLayers list(cap_metal_layer route_layer))
)

; --- MINUS pin → pixel2 center (90-degree M8 zigzag + via to AP) ---
mim_minus_box = fl_get_pin_boundary(cap_inst "MINUS")
when( mim_minus_box
    minus_cx = (xCoord(lowerLeft(mim_minus_box)) + xCoord(upperRight(mim_minus_box))) / 2.0
    minus_cy = (yCoord(lowerLeft(mim_minus_box)) + yCoord(upperRight(mim_minus_box))) / 2.0
    if( orient == "H" then
        dbCreatePath(cv cap_metal_layer
            list(list(minus_cx minus_cy) list(cx2 minus_cy) list(cx2 cy2))
            wire_width)
    else
        dbCreatePath(cv cap_metal_layer
            list(list(minus_cx minus_cy) list(minus_cx cy2) list(cx2 cy2))
            wire_width)
    )
    ; Via polygon at pixel2 center: cap_metal_layer → route_layer
    via_poly = list(
        list(cx2 - half_via cy2 - half_via)
        list(cx2 + half_via cy2 - half_via)
        list(cx2 + half_via cy2 + half_via)
        list(cx2 - half_via cy2 + half_via))
    dbCreatePolygon(cv cap_metal_layer via_poly)
    dbCreatePolygon(cv route_layer     via_poly)
    viaGenerateViasInArea(cv via_poly viaOptions
        ?topAndBottomLayers list(cap_metal_layer route_layer))
)

; --- BULK → ground ---
; H cap (R90):  BULK is on the left  — extend polygon further left  (−X direction)
; V cap (R180): BULK is on the right — extend polygon further right (+X direction)
mim_bulk_box = fl_get_pin_boundary(cap_inst "BULK")
when( mim_bulk_box
    let( (x_bl y_bl x_tr y_tr w_p h_p m_poly)
        x_bl = xCoord(lowerLeft(mim_bulk_box))
        y_bl = yCoord(lowerLeft(mim_bulk_box))
        x_tr = xCoord(upperRight(mim_bulk_box))
        y_tr = yCoord(upperRight(mim_bulk_box))
        w_p = 1.0  h_p = 2.0
        if( orient == "H" then
            ; BULK on left: extend polygon leftward from lowerLeft
            m_poly = list(
                list(x_bl - w_p y_bl)
                list(x_bl       y_bl)
                list(x_bl       y_bl + h_p)
                list(x_bl - w_p y_bl + h_p))
        else
            ; BULK on right: extend polygon rightward from upperRight
            m_poly = list(
                list(x_tr       y_bl)
                list(x_tr + w_p y_bl)
                list(x_tr + w_p y_tr)
                list(x_tr       y_tr))
        )
        dbCreatePolygon(cv "M5" m_poly)
        dbCreatePolygon(cv gnd_layer m_poly)
        viaGenerateViasInArea(cv m_poly viaOptions
            ?topAndBottomLayers list(gnd_layer "M5"))
    )
)

printf("  [cap pair %d] (%d,%d)↔(%d,%d) orient=%s midpoint=(%.2f,%.2f)\n"
       cp_idx r1 c1 r2 c2 orient mx my)

) ; end let
) ; end procedure fl_build_cap_pair

; ============================================================
; ENTRY POINT
; ============================================================
build_full_layout()
exit(0)
