; ============================================================
; AUTO-GENERATED SIMULATION SCRIPT — do not edit by hand
; Generated by VirtuosoPixelEngine from templates/sim.il
; ============================================================

; ============================================================
; MASTER WRAPPER
; ============================================================
procedure( run_full_rf_pixel_flow()
    let( (libName cellName dest_folder base_output
          s_param_pattern s_param_file report_file log_file)

        ; --- Configuration (filled in by Python engine) ---
        libName     = "${LIB_NAME}"
        cellName    = "${CELL_NAME}"
        dest_folder = "${DEST_FOLDER}"

        unless( isDir(dest_folder) createDir(dest_folder) )

        base_output     = strcat(dest_folder "/" cellName)
        s_param_pattern = strcat(base_output ".s%dp")
        s_param_file    = strcat(base_output ".s10p")
        report_file     = strcat(base_output "_emx.pin")
        log_file        = strcat(base_output "_emx.log")

        printf("--- STARTING AUTOMATED RF FLOW ---\n")
        printf("    Cell:   %s/%s\n" libName cellName)
        printf("    Output: %s\n"   dest_folder)

        rf_flow_run_emx(libName cellName dest_folder s_param_pattern report_file log_file)
        rf_flow_run_sim(dest_folder cellName s_param_file)

        printf("--- AUTOMATED RF FLOW COMPLETE ---\n")
    )
)

; ============================================================
; EMX EXTRACTION
; ============================================================
procedure( rf_flow_run_emx( libName cellName dest_folder s_param_pattern report_file log_file )
    let( (gds_file proc_file strmout_cmd emx_cmd sys_status bb_file bb_filename strmout_log)

        ; 1. Export GDSII
        printf(">> Exporting GDSII from Virtuoso...\n")
        gds_file    = strcat(dest_folder "/" cellName ".gds")
        strmout_log = strcat(dest_folder "/strmout.log")

        strmout_cmd = sprintf(nil
            "strmout -library %s -topCell %s -view layout -strmFile %s -logFile %s -pinAttNum 51"
            libName cellName gds_file strmout_log)

        printf("Executing: %s\n" strmout_cmd)
        sys_status = system(strmout_cmd)

        if( sys_status != 0 || !isFile(gds_file) then
            error("GDS export failed! Check %s for details." strmout_log)
        )
        printf(">> GDS Export Complete: %s\n" gds_file)

        ; 2. Generate Blackbox Rules
        bb_filename = strcat(dest_folder "/blackbox_cells.txt")
        bb_file = outfile(bb_filename)
        if( !bb_file then error("Could not create blackbox cells file!") )
        fprintf(bb_file "^nmos_rf.*\n")
        fprintf(bb_file "^mimcap.*\n")
        close(bb_file)

        ; 3. Run EMX
        printf(">> Running EMX Extraction...\n")
        proc_file = "${PROC_FILE}"

        emx_cmd = sprintf(nil
            "cd %s && ${EMX_BINARY} %s %s %s --sweep ${EMX_FREQ_START} ${EMX_FREQ_STOP} --sweep-stepsize ${EMX_FREQ_STEP} --device-cells-file %s -p PIX_OUT -p VSS -p GATE --message-file %s --log-time-level=0 --parallel ${EMX_PARALLEL} --recommended-memory --format touchstone2 -s %s --include-port-order --cadence-pins=51"
            dest_folder gds_file cellName proc_file bb_filename log_file s_param_pattern)

        printf("Executing: %s\n" emx_cmd)
        sys_status = system(emx_cmd)

        if( sys_status != 0 then error("EMX extraction failed! Check %s for details." log_file) )
        printf(">> EMX Complete. Results saved in %s\n" dest_folder)
    )
)

; ============================================================
; SPECTRE SIMULATION
; ============================================================
procedure( rf_flow_run_sim( dest_folder cellName s_param_file )
    let( (vctrl_vals netlist_path result_dir sim_log out_port sim_cmd idx s1p_path)
        printf(">> Starting Direct Spectre Simulation...\n")

        vctrl_vals = ${VCTRL_VALS_SKILL}
        idx = 0

        foreach( v vctrl_vals
            printf(">> Simulating Run %d with V_ctrl = %g V...\n" idx v)

            netlist_path = sprintf(nil "%s/tb_%s_run%d.scs" dest_folder cellName idx)
            result_dir   = sprintf(nil "%s/psf_run%d" dest_folder idx)

            out_port = outfile(netlist_path)
            fprintf(out_port "// Automated EMX Testbench for Run %d (V_ctrl = %gV)\n" idx v)
            fprintf(out_port "simulator lang=spectre\n\n")

            fprintf(out_port "include \"${TSMC_MODELS}\" section=tt_rfmos\n\n")
            fprintf(out_port "include \"${TSMC_MODELS}\" section=tt_rfmim\n\n")

            fprintf(out_port "parameters v_ctrl=%g\n\n" v)

            fprintf(out_port "emx_blk (gate 0 pix_out 0 vss 0 nmos_b 0 nmos_d 0 nmos_g 0 nmos_s 0 mim_p 0 mim_m 0 mim_b 0) nport file=\"%s\"\n\n" s_param_file)

            fprintf(out_port "// Re-inserting device models\n")
            fprintf(out_port "M0 (nmos_d nmos_g nmos_s nmos_b) nmos_rf wr=${NMOS_WIDTH} lr=${NMOS_LENGTH} nr=${NMOS_FINGERS}\n")
            fprintf(out_port "C0 (mim_p mim_m mim_b) ${MIM_CELL_SPECTRE} wt=${MIM_WIDTH} lt=${MIM_LENGTH}\n\n")

            fprintf(out_port "// Stimulus\n")
            fprintf(out_port "v_vss  (vss 0) vsource dc=0\n")
            fprintf(out_port "v_mimb (mim_b 0) vsource dc=0\n")
            fprintf(out_port "v_gate (gate 0) vsource dc=v_ctrl\n")
            fprintf(out_port "p1 (pix_out 0) port r=50 num=1\n\n")

            s1p_path = sprintf(nil "%s/%s_run%d.s1p" dest_folder cellName idx)
            fprintf(out_port "sp_sim sp ports=[p1] start=${SPECTRE_START} stop=${SPECTRE_STOP} step=${SPECTRE_STEP} file=\"%s\" datafmt=touchstone\n" s1p_path)
            close(out_port)

            ; Create result_dir up front so the Spectre log can go there
            unless( isDir(result_dir) createDir(result_dir) )
            sim_log = sprintf(nil "%s/spectre.log" result_dir)

            sim_cmd = sprintf(nil "spectre \"%s\" -raw \"%s\" > \"%s\" 2>&1" netlist_path result_dir sim_log)
            printf("Executing: %s\n" sim_cmd)
            system(sim_cmd)

            if( isDir(result_dir) then
                printf(">> Simulation %d complete. Data saved to %s\n" idx s1p_path)
            else
                warn("Simulation failed or result directory not found for Run %d!" idx)
            )

            idx = idx + 1
        )
        printf(">> All Simulations Complete!\n")
    )
)

; ============================================================
; ENTRY POINT
; ============================================================
run_full_rf_pixel_flow()
exit(0)
