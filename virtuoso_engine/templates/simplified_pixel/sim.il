; ============================================================
; AUTO-GENERATED SIMPLIFIED PIXEL SIMULATION SCRIPT — do not edit by hand
; Generated by VirtuosoPixelEngine from templates/simplified_sim.il
;
; Mode: simplified_pixel
;
; Flow:
;   1. Export GDS from Virtuoso layout.
;   2. Run EMX electromagnetic extraction with 3 ports:
;        Port 1 — PIX_OUT  (RF measurement port)
;        Port 2 — VSS      (ground reference)
;        Port 3 — CENTER   (switch connection node)
;   3. Run Spectre twice with compact switch circuit models:
;
;        Run 0 — switch ON  state:
;          CENTER → cap_value → sw_mid → r_on → GND
;          (models transistor in conduction; r_on is small,
;           imaginary part of cap is negligible at these frequencies)
;
;        Run 1 — switch OFF state:
;          CENTER → cap_value → sw_mid1 → r_off → sw_mid2 → c_off → GND
;          (models transistor off; high impedance path with
;           parasitic r_off and c_off from drain-source junction)
;
;   Output: two .s1p files (run0 = on, run1 = off) with S11 at PIX_OUT.
; ============================================================

; ============================================================
; MASTER WRAPPER
; ============================================================
procedure( run_simplified_pixel_flow()
    let( (libName cellName dest_folder base_output
          s_param_pattern s_param_file report_file log_file)

        ; --- Configuration (filled in by Python engine) ---
        libName     = "${LIB_NAME}"
        cellName    = "${CELL_NAME}"
        dest_folder = "${DEST_FOLDER}"

        unless( isDir(dest_folder) createDir(dest_folder) )

        base_output     = strcat(dest_folder "/" cellName)
        s_param_pattern = strcat(base_output ".s%dp")
        s_param_file    = strcat(base_output ".s3p")   ; 3 external ports → .s3p
        report_file     = strcat(base_output "_emx.pin")
        log_file        = strcat(base_output "_emx.log")

        printf("--- STARTING SIMPLIFIED PIXEL RF FLOW ---\n")
        printf("    Cell:   %s/%s\n" libName cellName)
        printf("    Output: %s\n"   dest_folder)

        simplified_run_emx(libName cellName dest_folder
                           s_param_pattern report_file log_file)
        simplified_run_sim(dest_folder cellName s_param_file)

        printf("--- SIMPLIFIED PIXEL RF FLOW COMPLETE ---\n")
    )
)

; ============================================================
; EMX ELECTROMAGNETIC EXTRACTION (3 ports — no blackbox devices)
; ============================================================
procedure( simplified_run_emx( libName cellName dest_folder
                                s_param_pattern report_file log_file )
    let( (gds_file proc_file strmout_cmd emx_cmd sys_status strmout_log)

        ; 1. Export GDSII
        printf(">> Exporting GDSII from Virtuoso...\n")
        gds_file    = strcat(dest_folder "/" cellName ".gds")
        strmout_log = strcat(dest_folder "/strmout.log")

        strmout_cmd = sprintf(nil
            "strmout -library %s -topCell %s -view layout -strmFile %s -logFile %s -pinAttNum 51"
            libName cellName gds_file strmout_log)

        printf("Executing: %s\n" strmout_cmd)
        sys_status = system(strmout_cmd)

        if( sys_status != 0 || !isFile(gds_file) then
            error("GDS export failed! Check %s for details." strmout_log)
        )
        printf(">> GDS Export Complete: %s\n" gds_file)

        ; 2. Run EMX
        ;    No --device-cells-file: the simplified layout has no sub-cell devices.
        ;    Three ports: PIX_OUT (RF), VSS (ground ref), CENTER (switch node).
        printf(">> Running EMX Extraction (3-port: PIX_OUT, VSS, CENTER)...\n")
        proc_file = "${PROC_FILE}"

        emx_cmd = sprintf(nil
            "cd %s && ${EMX_BINARY} %s %s %s --sweep ${EMX_FREQ_START} ${EMX_FREQ_STOP} --sweep-stepsize ${EMX_FREQ_STEP} -p PIX_OUT -p VSS -p CENTER --message-file %s --log-time-level=0 --parallel ${EMX_PARALLEL} --simultaneous-frequencies=0 --recommended-memory --format touchstone2 -s %s --include-port-order --cadence-pins=51"
            dest_folder gds_file cellName proc_file log_file s_param_pattern)

        printf("Executing: %s\n" emx_cmd)
        sys_status = system(emx_cmd)

        if( sys_status != 0 then
            error("EMX extraction failed! Check %s for details." log_file)
        )
        printf(">> EMX Complete. Results saved in %s\n" dest_folder)
    )
)

; ============================================================
; SPECTRE SIMULATION WITH SWITCH CIRCUIT MODELS
;
; Switch model parameters (substituted by Python engine):
;   ${CAP_VALUE}  — series coupling capacitance (F)
;   ${R_ON}       — on-state  resistance (ohm)
;   ${R_OFF}      — off-state resistance (ohm)
;   ${C_OFF}      — off-state capacitance (F)
; ============================================================
procedure( simplified_run_sim( dest_folder cellName s_param_file )
    let( (states state netlist_path result_dir sim_log out_port sim_cmd idx s1p_path)

        printf(">> Starting Simplified Pixel Spectre Simulation...\n")
        printf("   Switch model — CAP: ${CAP_VALUE} F  |  R_on: ${R_ON} Ohm"
               "  |  R_off: ${R_OFF} Ohm  |  C_off: ${C_OFF} F\n")

        states = list("on" "off")
        idx    = 0

        foreach( state states
            printf(">> Simulating Run %d: switch %s state\n" idx state)

            netlist_path = sprintf(nil "%s/tb_%s_%s.scs" dest_folder cellName state)
            result_dir   = sprintf(nil "%s/psf_%s" dest_folder state)
            s1p_path     = sprintf(nil "%s/%s_run%d.s1p" dest_folder cellName idx)

            out_port = outfile(netlist_path)

            ; --- Header ---
            fprintf(out_port "// Simplified Pixel Testbench — switch %s state\n" state)
            fprintf(out_port "// EMX 3-port: PIX_OUT(1), VSS(2), CENTER(3)\n")
            fprintf(out_port "simulator lang=spectre\n\n")

            ; --- EMX nport block ---
            ; Port order matches the EMX -p flag order above.
            ; Each port is referenced against node 0 (global ground).
            fprintf(out_port
                "emx_blk (center 0 pix_out 0 vss 0) nport file=\"%s\"\n\n"
                s_param_file)

            ; --- Ground reference for VSS port ---
            fprintf(out_port "v_vss (vss 0) vsource dc=0\n\n")

            ; --- Compact switch circuit model ---
            if( state == "on" then
                ; ON state: series cap + small r_on → GND
                ; The capacitor models the AC coupling through the pixel stack.
                ; r_on models the transistor channel resistance (~ 3 Ohm).
                ; Imaginary contribution of r_on is negligible.
                fprintf(out_port "// ON state: CENTER — c_sw — r_sw — GND\n")
                fprintf(out_port
                    "c_sw (center sw_mid) capacitor c=${CAP_VALUE}\n")
                fprintf(out_port
                    "r_sw (sw_mid 0) resistor r=${R_ON}\n\n")
            else
                ; OFF state: series cap + r_off + c_off → GND
                ; r_off models drain-source leakage resistance (~ 260 Ohm).
                ; c_off models drain-source parasitic capacitance (~ 80 fF).
                fprintf(out_port
                    "// OFF state: CENTER — c_sw — r_off_comp — c_off_comp — GND\n")
                fprintf(out_port
                    "c_sw      (center sw_mid1) capacitor c=${CAP_VALUE}\n")
                fprintf(out_port
                    "r_off_comp (sw_mid1 0) resistor r=${R_OFF}\n")
                fprintf(out_port
                    "c_off_comp (sw_mid1 0) capacitor c=${C_OFF}\n\n")
            )

            ; --- RF port and S-parameter analysis ---
            fprintf(out_port "p1 (pix_out 0) port r=50 num=1\n\n")
            fprintf(out_port
                "sp_sim sp ports=[p1] start=${SPECTRE_START} stop=${SPECTRE_STOP} step=${SPECTRE_STEP} file=\"%s\" datafmt=touchstone\n"
                s1p_path)

            close(out_port)

            ; --- Execute Spectre ---
            unless( isDir(result_dir) createDir(result_dir) )
            sim_log = sprintf(nil "%s/spectre.log" result_dir)
            sim_cmd = sprintf(nil
                "spectre \"%s\" -raw \"%s\" > \"%s\" 2>&1"
                netlist_path result_dir sim_log)

            printf("Executing: %s\n" sim_cmd)
            system(sim_cmd)

            if( isDir(result_dir) then
                printf(">> Simulation %d (%s state) complete. Data: %s\n"
                       idx state s1p_path)
            else
                warn("Simulation %d (%s state): result directory not found!" idx state)
            )

            idx = idx + 1
        )

        printf(">> All Simplified Pixel Simulations Complete!\n")
    )
)

; ============================================================
; ENTRY POINT
; ============================================================
run_simplified_pixel_flow()
exit(0)
