; ============================================================
; AUTO-GENERATED SIMPLIFIED PIXEL LAYOUT SCRIPT — do not edit by hand
; Generated by VirtuosoPixelEngine from templates/simplified_layout.il
;
; Mode: simplified_pixel
;
; This script draws only the two electrically significant layers:
;   - pixel_layer (e.g. M9): the top radiating element
;   - gnd_layer   (e.g. M4): the ground shield beneath the pixel
;
; Three layout pins are created for EMX port extraction:
;   PIX_OUT — top edge center of pixel_layer (port 1, RF input)
;   VSS     — right edge center of gnd_layer  (port 2, ground ref)
;   CENTER  — center of pixel_layer            (port 3, switch node)
;
; After EMX extracts a 3-port S-parameter, Spectre re-connects
; the CENTER port to a compact switch circuit model (see simplified_sim.il).
; ============================================================

procedure( build_simplified_pixel()
let( (cv libName layoutName
      pixel_size gnd_layer pixel_layer
      half pix_box gnd_box)

; ============================================================
; 1. USER CONFIGURATION  (filled in by Python engine)
; ============================================================
libName     = "${LIB_NAME}"
layoutName  = "${CELL_NAME}"
pixel_size  = ${PIXEL_SIZE}
gnd_layer   = "${GND_LAYER}"
pixel_layer = "${PIXEL_LAYER}"

; ============================================================
; 2. INITIALIZATION
; ============================================================
cv = dbOpenCellViewByType(libName layoutName "layout" "maskLayout" "w")
printf("--- Generating Simplified Pixel: %s/%s ---\n" libName layoutName)
printf("    Pixel size: %.2f um on %s / %s\n" pixel_size pixel_layer gnd_layer)

half = pixel_size / 2.0

; ============================================================
; 3. DRAW TOP RADIATING LAYER (pixel_layer)
; ============================================================
pix_box = list(list(-half -half) list(half half))
dbCreateRect(cv pixel_layer pix_box)
printf(" [3] Top pixel layer (%s) drawn: %.1f x %.1f um\n"
       pixel_layer pixel_size pixel_size)

; ============================================================
; 4. DRAW GROUND SHIELD LAYER (gnd_layer)
; ============================================================
gnd_box = list(list(-half -half) list(half half))
dbCreateRect(cv gnd_layer gnd_box)
printf(" [4] Ground shield layer (%s) drawn.\n" gnd_layer)

; ============================================================
; 5. CREATE LAYOUT PINS FOR EMX PORT EXTRACTION
; ============================================================

; --- Port 1: PIX_OUT — top edge center of pixel layer ---
let( (pin_bbox)
    pin_bbox = list(list(-0.5 half - 0.5) list(0.5 half))
    create_simplified_edge_pin(cv "PIX_OUT" list(pixel_layer "pin") pin_bbox "output")
    printf(" [5a] PIX_OUT pin placed at top edge of %s.\n" pixel_layer)
)

; --- Port 2: VSS — right edge center of ground layer ---
let( (pin_bbox)
    pin_bbox = list(list(half - 0.5 -0.5) list(half 0.5))
    create_simplified_edge_pin(cv "VSS" list(gnd_layer "pin") pin_bbox "inputOutput")
    printf(" [5b] VSS pin placed at right edge of %s.\n" gnd_layer)
)

; --- Port 3: CENTER — center of pixel layer (switch connection point) ---
let( (pin_bbox)
    pin_bbox = list(list(-0.25 -0.25) list(0.25 0.25))
    create_simplified_edge_pin(cv "CENTER" list(pixel_layer "pin") pin_bbox "inputOutput")
    printf(" [5c] CENTER pin placed at pixel center.\n")
)

dbSave(cv)
dbClose(cv)
printf("--- Simplified Pixel Layout Complete: %s ---\n" layoutName)
)
)

; ============================================================
; HELPER FUNCTIONS
; ============================================================

procedure( create_simplified_edge_pin(cv netName layerName bbox termDir)
    let( (net term fig pin)
        net = dbFindNetByName(cv netName)
        unless(net net = dbCreateNet(cv netName))

        term = dbFindTermByName(cv netName)
        unless(term term = dbCreateTerm(net netName termDir))

        fig = dbCreateRect(cv layerName bbox)
        pin = dbCreatePin(net fig netName)

        dbCreateLabel(cv layerName car(bbox) netName "centerCenter" "R0" "roman" 0.5)
        pin
    )
)

; ============================================================
; ENTRY POINT
; ============================================================
build_simplified_pixel()
exit(0)
