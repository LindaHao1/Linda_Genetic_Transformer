; ============================================================
; AUTO-GENERATED DIFFERENTIAL FILTER — LAYOUT SCRIPT
; Do not edit by hand.
; Generated by VirtuosoPixelEngine from
;   templates/differential_filter/layout.il
;
; This is the pixelated_design_simple layout with a differential I/O port set.
; The Python engine has already MIRRORED the GA half-design about the bottom
; row, so ``pixel_types`` here is the FULL (2R-1)-row matrix.
;
; Coordinate convention (identical to pixelated_design_simple)
;   Origin at lower-left corner of the pixel grid.
;   col 0 = LEFT feed column, col (num_cols-1) = RIGHT feed column.
;   Row i maps to y_center = (num_rows - 1 - i) * grid_size + grid_size/2.
;
; Pins (differential)
;   PIX_IN_T  / PIX_IN_T_GND  — top    input, left feed col, row IN_TOP
;   PIX_IN_B  / PIX_IN_B_GND  — bottom input, left feed col, row IN_BOT
;   PIX_OUT   / PIX_OUT_GND   — output, right feed col, axis row OUT
;   (Signal pins on pixel_layer, GND refs on gnd_layer at the same x/y.)
; ============================================================

procedure( build_differential_filter()
let( (cv libName cellName
      pixel_size grid_size gnd_layer pixel_layer
      num_rows num_cols pixel_types pixel_sizes port_names this_size
      feedline_row_in_top feedline_row_in_bot feedline_row_out
      feedline_width_in feedline_width_out feedline_padding gnd_y_extension
      fl_in_top_y_center fl_in_top_y_bottom fl_in_top_y_top
      fl_in_bot_y_center fl_in_bot_y_bottom fl_in_bot_y_top
      fl_out_y_center    fl_out_y_bottom    fl_out_y_top
      gnd_y_bottom gnd_y_top
      fl_x_left fl_x_right
      ptype pname center_x center_y
      patch_left patch_bottom patch_right patch_top
      pin_size pin_box feedline_pin_size_in feedline_pin_size_out)

; ============================================================
; 1. USER CONFIGURATION  (filled in by Python engine)
; ============================================================
libName             = "${LIB_NAME}"
cellName            = "${CELL_NAME}"
pixel_size          = ${PIXEL_SIZE}      ; metal patch size (um); may be > grid_size
grid_size           = ${GRID_SIZE}       ; pitch between pixel centres (um)
gnd_layer           = "${GND_LAYER}"
pixel_layer         = "${PIXEL_LAYER}"
num_rows            = ${NUM_ROWS}        ; FULL mirrored row count (2R-1)
num_cols            = ${NUM_COLS}
pixel_types         = ${PIXEL_TYPES_SKILL}
pixel_sizes         = ${PIXEL_SIZES_SKILL}
port_names          = ${PORT_NAMES_SKILL}
feedline_row_in_top = ${FEEDLINE_ROW_IN_TOP}   ; top    input row (full-matrix coords)
feedline_row_in_bot = ${FEEDLINE_ROW_IN_BOT}   ; bottom input row (mirror)
feedline_row_out    = ${FEEDLINE_ROW_OUT}      ; output row (axis row)
feedline_width_in   = ${FEEDLINE_WIDTH_IN}
feedline_width_out  = ${FEEDLINE_WIDTH_OUT}
feedline_padding    = ${FEEDLINE_PADDING}
gnd_y_extension     = ${GND_Y_EXTENSION}

; ============================================================
; 2. INITIALIZATION
; ============================================================
cv = dbOpenCellViewByType(libName cellName "layout" "maskLayout" "w")
unless(cv
    fprintf(errport "*Warning* [PixelEngine] Cannot lock %s/%s — purging stale cell and retrying.\n"
            libName cellName)
    let((staleCell)
        staleCell = ddGetObj(libName cellName)
        when(staleCell ddDeleteObj(staleCell))
    )
    cv = dbOpenCellViewByType(libName cellName "layout" "maskLayout" "w")
)
unless(cv
    error("*Error* [PixelEngine] Failed to open/create layout cell view for %s/%s\n"
          libName cellName)
)
printf("--- Generating Differential Filter: %s/%s ---\n" libName cellName)
printf("    Grid (full): %dx%d  pixel_size=%.2f um  grid_size=%.2f um\n"
       num_rows num_cols pixel_size grid_size)

pin_size             = 0.5
feedline_pin_size_in  = feedline_width_in
feedline_pin_size_out = feedline_width_out

; Row i:  y_center = (num_rows - 1 - i) * grid_size + grid_size/2
fl_in_top_y_center = (num_rows - 1 - feedline_row_in_top) * grid_size + grid_size / 2.0
fl_in_top_y_bottom = fl_in_top_y_center - feedline_width_in / 2.0
fl_in_top_y_top    = fl_in_top_y_center + feedline_width_in / 2.0

fl_in_bot_y_center = (num_rows - 1 - feedline_row_in_bot) * grid_size + grid_size / 2.0
fl_in_bot_y_bottom = fl_in_bot_y_center - feedline_width_in / 2.0
fl_in_bot_y_top    = fl_in_bot_y_center + feedline_width_in / 2.0

fl_out_y_center    = (num_rows - 1 - feedline_row_out) * grid_size + grid_size / 2.0
fl_out_y_bottom    = fl_out_y_center - feedline_width_out / 2.0
fl_out_y_top       = fl_out_y_center + feedline_width_out / 2.0

gnd_y_bottom = 0.0 - gnd_y_extension
gnd_y_top    = num_rows * grid_size + gnd_y_extension

fl_x_left  = 0.0 - feedline_padding
fl_x_right = num_cols * grid_size + feedline_padding

; ============================================================
; 3. DRAW PIXEL GRID  (col-first, then row)
; ============================================================
for( col_i 0 (num_cols - 1)

    if( col_i == 0 || col_i == (num_cols - 1) then

        ; ---- FEED COLUMN: feedline trace(s) + full-height ground ----
        let( (fc_x_left fc_x_right)
            fc_x_left  = col_i * grid_size
            fc_x_right = (col_i + 1) * grid_size

            if( col_i == 0 then
                ; LEFT feed column: two input traces (top + bottom)
                dbCreateRect(cv pixel_layer
                    list(list(fc_x_left fl_in_top_y_bottom) list(fc_x_right fl_in_top_y_top)))
                dbCreateRect(cv pixel_layer
                    list(list(fc_x_left fl_in_bot_y_bottom) list(fc_x_right fl_in_bot_y_top)))
            else
                ; RIGHT feed column: single output trace (axis row)
                dbCreateRect(cv pixel_layer
                    list(list(fc_x_left fl_out_y_bottom) list(fc_x_right fl_out_y_top)))
            )
            dbCreateRect(cv gnd_layer
                list(list(fc_x_left gnd_y_bottom) list(fc_x_right gnd_y_top)))
        )

    else

        ; ---- ACTIVE COLUMN: full-height ground + per-row pixel patches ----
        let( (ac_x_left ac_x_right)
            ac_x_left  = col_i * grid_size
            ac_x_right = (col_i + 1) * grid_size
            dbCreateRect(cv gnd_layer
                list(list(ac_x_left gnd_y_bottom) list(ac_x_right gnd_y_top)))
        )

        for( row_i 0 (num_rows - 1)

            let( (flat_idx_inner)
                flat_idx_inner = row_i * num_cols + col_i
                ptype = nth(flat_idx_inner pixel_types)
                pname = nth(flat_idx_inner port_names)
                this_size = nth(flat_idx_inner pixel_sizes)
            )

            center_x = col_i * grid_size + grid_size / 2.0
            center_y = (num_rows - 1 - row_i) * grid_size + grid_size / 2.0

            ; --- Top metal patch (types > 0) ---
            when( ptype > 0
                patch_left   = center_x - this_size / 2.0
                patch_bottom = center_y - this_size / 2.0
                patch_right  = center_x + this_size / 2.0
                patch_top    = center_y + this_size / 2.0
                dbCreateRect(cv pixel_layer
                    list(list(patch_left patch_bottom) list(patch_right patch_top)))
            )

            ; --- Central port pin (types > 1; never fires for 0/1-only) ---
            when( ptype > 1
                pin_box = list(
                    list(center_x - pin_size/2.0  center_y - pin_size/2.0)
                    list(center_x + pin_size/2.0  center_y + pin_size/2.0))
                diff_create_pin(cv pname list(pixel_layer "pin") pin_box "inputOutput")
            )
        )
    )
)

printf(" [3] Pixel grid drawn: %d rows x %d cols\n" num_rows num_cols)

; ============================================================
; 4. DRAW FEEDLINE EXTENSIONS  (beyond the grid)
;    Left: two input extensions.  Right: one output extension.
; ============================================================
; --- Left input extensions (top + bottom) ---
dbCreateRect(cv pixel_layer
    list(list(fl_x_left fl_in_top_y_bottom) list(0.0 fl_in_top_y_top)))
dbCreateRect(cv pixel_layer
    list(list(fl_x_left fl_in_bot_y_bottom) list(0.0 fl_in_bot_y_top)))
dbCreateRect(cv gnd_layer
    list(list(fl_x_left gnd_y_bottom) list(0.0 gnd_y_top)))

; --- Right output extension (axis row) ---
dbCreateRect(cv pixel_layer
    list(list(num_cols * grid_size fl_out_y_bottom) list(fl_x_right fl_out_y_top)))
dbCreateRect(cv gnd_layer
    list(list(num_cols * grid_size gnd_y_bottom) list(fl_x_right gnd_y_top)))

printf(" [4] Left input extensions at y=%.2f,%.2f  right output at y=%.2f\n"
       fl_in_top_y_center fl_in_bot_y_center fl_out_y_center)

; ============================================================
; 5. PLACE DIFFERENTIAL I/O AND GROUND PINS
; ============================================================
; --- PIX_IN_T (top input) + gnd ref ---
let( (pin_box)
    pin_box = list(
        list(fl_x_left              fl_in_top_y_center - feedline_pin_size_in/2.0)
        list(fl_x_left + pin_size   fl_in_top_y_center + feedline_pin_size_in/2.0))
    diff_create_pin(cv "PIX_IN_T" list(pixel_layer "pin") pin_box "input")
    diff_create_pin(cv "PIX_IN_T_GND" list(gnd_layer "pin") pin_box "inputOutput")
    printf(" [5a] PIX_IN_T  at x=%.2f y=%.2f\n" fl_x_left fl_in_top_y_center)
)

; --- PIX_IN_B (bottom input) + gnd ref ---
let( (pin_box)
    pin_box = list(
        list(fl_x_left              fl_in_bot_y_center - feedline_pin_size_in/2.0)
        list(fl_x_left + pin_size   fl_in_bot_y_center + feedline_pin_size_in/2.0))
    diff_create_pin(cv "PIX_IN_B" list(pixel_layer "pin") pin_box "input")
    diff_create_pin(cv "PIX_IN_B_GND" list(gnd_layer "pin") pin_box "inputOutput")
    printf(" [5b] PIX_IN_B  at x=%.2f y=%.2f\n" fl_x_left fl_in_bot_y_center)
)

; --- PIX_OUT (output) + gnd ref ---
let( (pin_box)
    pin_box = list(
        list(fl_x_right - pin_size  fl_out_y_center - feedline_pin_size_out/2.0)
        list(fl_x_right             fl_out_y_center + feedline_pin_size_out/2.0))
    diff_create_pin(cv "PIX_OUT" list(pixel_layer "pin") pin_box "output")
    diff_create_pin(cv "PIX_OUT_GND" list(gnd_layer "pin") pin_box "inputOutput")
    printf(" [5c] PIX_OUT   at x=%.2f y=%.2f\n" fl_x_right fl_out_y_center)
)

; ============================================================
; 6. SAVE AND CLOSE
; ============================================================
dbSave(cv)
dbClose(cv)
printf("--- Differential Filter Layout Complete: %s ---\n" cellName)
)
)

; ============================================================
; HELPER: create a layout pin (net + term + rect + label)
; ============================================================
procedure( diff_create_pin(cv netName layerName bbox termDir)
    let( (net term fig pin)
        net  = dbFindNetByName(cv netName)
        unless(net  net  = dbCreateNet(cv netName))

        term = dbFindTermByName(cv netName)
        unless(term term = dbCreateTerm(net netName termDir))

        fig  = dbCreateRect(cv layerName bbox)
        pin  = dbCreatePin(net fig netName)

        dbCreateLabel(cv layerName car(bbox) netName "centerCenter" "R0" "roman" 0.5)
        pin
    )
)

; ============================================================
; ENTRY POINT
; ============================================================
build_differential_filter()
exit(0)
