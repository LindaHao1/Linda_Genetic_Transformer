; ============================================================
; AUTO-GENERATED PIXELATED DESIGN SIMPLE — LAYOUT SCRIPT
; Do not edit by hand.
; Generated by VirtuosoPixelEngine from
;   templates/pixelated_design_simple/layout.il
;
; Coordinate convention
; ---------------------
;   Origin at lower-left corner of the pixel grid.
;   col increases to the right (+x), pitch = grid_size
;   row increases upward      (+y), pitch = grid_size
;
;   col 0            = LEFT  FEED COLUMN  (feedline trace only, no pixel patch)
;   col (num_cols-1) = RIGHT FEED COLUMN  (feedline trace only, no pixel patch)
;   cols 1 .. num_cols-2 = ACTIVE PIXEL COLUMNS
;
; Metal patch (pixel_layer)
;   Drawn as pixel_size × pixel_size, centered in the grid cell.
;   pixel_size >= grid_size is allowed — creates deliberate metal overlap
;   between adjacent active pixels for EM coupling.
;
; Ground plane (gnd_layer)
;   Active columns: one rectangle per column, width = grid_size,
;     height = num_rows * grid_size + 2 * gnd_y_extension.
;   Feed columns + feedline extensions: narrow strip of height = feedline_width,
;     aligned with the feedline centre (no full-height ground).
;
; Pins
;   PIX_IN      — pixel_layer, far-left  feedline end (input)
;   PIX_OUT     — pixel_layer, far-right feedline end (output)
;   PIX_IN_GND  — gnd_layer,  same x/y  as PIX_IN    (ground reference)
;   PIX_OUT_GND — gnd_layer,  same x/y  as PIX_OUT   (ground reference)
;   IND_<i>     — pixel_layer, inductor pixel central ports (row-first)
;   SW_<i>      — pixel_layer, switch  pixel central ports  (row-first)
; ============================================================

procedure( build_pixelated_simple()
let( (cv libName cellName
      pixel_size grid_size gnd_layer pixel_layer
      num_rows num_cols pixel_types port_names
      feedline_row feedline_width feedline_padding gnd_y_extension
      fl_y_center fl_y_bottom fl_y_top
      gnd_y_bottom gnd_y_top
      fl_x_left fl_x_right
      ptype pname center_x center_y
      patch_left patch_bottom patch_right patch_top
      pin_size pin_box feedline_pin_size)

; ============================================================
; 1. USER CONFIGURATION  (filled in by Python engine)
; ============================================================
libName          = "${LIB_NAME}"
cellName         = "${CELL_NAME}"
pixel_size       = ${PIXEL_SIZE}      ; metal patch size (um); may be > grid_size
grid_size        = ${GRID_SIZE}       ; pitch between pixel centres (um)
gnd_layer        = "${GND_LAYER}"
pixel_layer      = "${PIXEL_LAYER}"
num_rows         = ${NUM_ROWS}
num_cols         = ${NUM_COLS}
pixel_types      = ${PIXEL_TYPES_SKILL}
port_names       = ${PORT_NAMES_SKILL}
feedline_row     = ${FEEDLINE_ROW}
feedline_width   = ${FEEDLINE_WIDTH}
feedline_padding = ${FEEDLINE_PADDING}
gnd_y_extension  = ${GND_Y_EXTENSION}

; ============================================================
; 2. INITIALIZATION
; ============================================================
cv = dbOpenCellViewByType(libName cellName "layout" "maskLayout" "w")
printf("--- Generating Pixelated Design Simple: %s/%s ---\n" libName cellName)
printf("    Grid: %dx%d  pixel_size=%.2f um  grid_size=%.2f um  gnd_ext=%.2f um\n"
       num_rows num_cols pixel_size grid_size gnd_y_extension)

pin_size         = 0.5             ; um — central port pin size
feedline_pin_size = feedline_width ; feedline port pin height = feedline width

; Feedline Y geometry (derived from grid_size pitch)
fl_y_center = feedline_row * grid_size + grid_size / 2.0
fl_y_bottom = fl_y_center - feedline_width / 2.0
fl_y_top    = fl_y_center + feedline_width / 2.0

; Ground Y extent for active columns (grid height + bilateral extension)
gnd_y_bottom = 0.0 - gnd_y_extension
gnd_y_top    = num_rows * grid_size + gnd_y_extension

; Feedline X extent (includes extensions beyond the grid)
fl_x_left  = 0.0 - feedline_padding
fl_x_right = num_cols * grid_size + feedline_padding

; ============================================================
; 3. DRAW PIXEL GRID  (col-first, then row)
; ============================================================
for( col_i 0 (num_cols - 1)

    if( col_i == 0 || col_i == (num_cols - 1) then

        ; ---- FEED COLUMN: feedline trace (feedline_width) + full-height ground ----
        ;  No pixel patch is drawn.  Top metal height = feedline_width only.
        ;  Ground height = gnd_y_bottom → gnd_y_top (same as active columns)
        ;  so the ground plane is one continuous rectangle across all columns.
        let( (fc_x_left fc_x_right)
            fc_x_left  = col_i * grid_size
            fc_x_right = (col_i + 1) * grid_size

            dbCreateRect(cv pixel_layer
                list(list(fc_x_left fl_y_bottom) list(fc_x_right fl_y_top)))
            dbCreateRect(cv gnd_layer
                list(list(fc_x_left gnd_y_bottom) list(fc_x_right gnd_y_top)))
            printf("  [feed col %d] metal y=[%.2f,%.2f]  gnd y=[%.2f,%.2f]\n"
                   col_i fl_y_bottom fl_y_top gnd_y_bottom gnd_y_top)
        )

    else

        ; ---- ACTIVE COLUMN: full-height ground + per-row pixel patches ----
        let( (ac_x_left ac_x_right)
            ac_x_left  = col_i * grid_size
            ac_x_right = (col_i + 1) * grid_size

            ; Ground tile for this entire column (extended in Y)
            dbCreateRect(cv gnd_layer
                list(list(ac_x_left gnd_y_bottom) list(ac_x_right gnd_y_top)))
        )

        for( row_i 0 (num_rows - 1)

            let( (flat_idx_inner)
                flat_idx_inner = row_i * num_cols + col_i
                ptype = nth(flat_idx_inner pixel_types)
                pname = nth(flat_idx_inner port_names)
            )

            center_x = col_i * grid_size + grid_size / 2.0
            center_y = row_i * grid_size + grid_size / 2.0

            ; --- Top metal patch (types 1, 2, 3): pixel_size centred in cell ---
            when( ptype > 0
                patch_left   = center_x - pixel_size / 2.0
                patch_bottom = center_y - pixel_size / 2.0
                patch_right  = center_x + pixel_size / 2.0
                patch_top    = center_y + pixel_size / 2.0
                dbCreateRect(cv pixel_layer
                    list(list(patch_left patch_bottom) list(patch_right patch_top)))
            )

            ; --- Central port pin (types 2 and 3) ---
            when( ptype > 1
                pin_box = list(
                    list(center_x - pin_size/2.0  center_y - pin_size/2.0)
                    list(center_x + pin_size/2.0  center_y + pin_size/2.0))
                pixsimple_create_pin(cv pname list(pixel_layer "pin") pin_box "inputOutput")
                printf("  [pixel %d,%d type=%d] Central pin: %s\n"
                       row_i col_i ptype pname)
            )
        )
    )
)

printf(" [3] Pixel grid drawn: %d rows x %d cols\n" num_rows num_cols)

; ============================================================
; 4. DRAW FEEDLINE EXTENSIONS  (beyond the grid, left and right)
;
;    Left  extension: x = [-feedline_padding, 0]
;    Right extension: x = [num_cols*grid_size, num_cols*grid_size + feedline_padding]
;
;    Each extension draws both the top-metal trace and a matching
;    ground strip (feedline_width height, centred on fl_y_center).
; ============================================================

; --- Left extension ---
; Top metal: feedline_width only (the signal trace)
; Ground:    full height gnd_y_bottom → gnd_y_top (continuous with pixel-grid ground)
dbCreateRect(cv pixel_layer
    list(list(fl_x_left fl_y_bottom) list(0.0 fl_y_top)))
dbCreateRect(cv gnd_layer
    list(list(fl_x_left gnd_y_bottom) list(0.0 gnd_y_top)))

; --- Right extension ---
; Top metal: feedline_width only (the signal trace)
; Ground:    full height gnd_y_bottom → gnd_y_top (continuous with pixel-grid ground)
dbCreateRect(cv pixel_layer
    list(list(num_cols * grid_size fl_y_bottom) list(fl_x_right fl_y_top)))
dbCreateRect(cv gnd_layer
    list(list(num_cols * grid_size gnd_y_bottom) list(fl_x_right gnd_y_top)))

printf(" [4] Feedline extensions: left x=[%.2f, 0]  right x=[%.2f, %.2f]\n"
       fl_x_left (num_cols * grid_size) fl_x_right)

; ============================================================
; 5. PLACE I/O AND GROUND PINS  (at feedline ends)
;
;   PIX_IN  / PIX_IN_GND  — left  end (x = fl_x_left)
;   PIX_OUT / PIX_OUT_GND — right end (x = fl_x_right)
;
;   Signal pins (PIX_IN / PIX_OUT) are on pixel_layer.
;   Ground pins (PIX_IN_GND / PIX_OUT_GND) are on gnd_layer
;   at the exact same x/y position — used as the EMX ground
;   reference ports.
; ============================================================

; --- PIX_IN (pixel_layer, left end) ---
let( (pin_box)
    pin_box = list(
        list(fl_x_left              fl_y_center - feedline_pin_size/2.0)
        list(fl_x_left + pin_size   fl_y_center + feedline_pin_size/2.0))
    pixsimple_create_pin(cv "PIX_IN" list(pixel_layer "pin") pin_box "input")
    printf(" [5a] PIX_IN     on %-3s  at x=%.2f\n" pixel_layer fl_x_left)
)

; --- PIX_IN_GND (gnd_layer, same position) ---
let( (pin_box)
    pin_box = list(
        list(fl_x_left              fl_y_center - feedline_pin_size/2.0)
        list(fl_x_left + pin_size   fl_y_center + feedline_pin_size/2.0))
    pixsimple_create_pin(cv "PIX_IN_GND" list(gnd_layer "pin") pin_box "inputOutput")
    printf(" [5b] PIX_IN_GND on %-3s  at x=%.2f\n" gnd_layer fl_x_left)
)

; --- PIX_OUT (pixel_layer, right end) ---
let( (pin_box)
    pin_box = list(
        list(fl_x_right - pin_size  fl_y_center - feedline_pin_size/2.0)
        list(fl_x_right             fl_y_center + feedline_pin_size/2.0))
    pixsimple_create_pin(cv "PIX_OUT" list(pixel_layer "pin") pin_box "output")
    printf(" [5c] PIX_OUT    on %-3s  at x=%.2f\n" pixel_layer fl_x_right)
)

; --- PIX_OUT_GND (gnd_layer, same position) ---
let( (pin_box)
    pin_box = list(
        list(fl_x_right - pin_size  fl_y_center - feedline_pin_size/2.0)
        list(fl_x_right             fl_y_center + feedline_pin_size/2.0))
    pixsimple_create_pin(cv "PIX_OUT_GND" list(gnd_layer "pin") pin_box "inputOutput")
    printf(" [5d] PIX_OUT_GND on %-3s at x=%.2f\n" gnd_layer fl_x_right)
)

; ============================================================
; 6. SAVE AND CLOSE
; ============================================================
dbSave(cv)
dbClose(cv)
printf("--- Pixelated Design Simple Layout Complete: %s ---\n" cellName)
)
)

; ============================================================
; HELPER: create a layout pin (net + term + rect + label)
; ============================================================
procedure( pixsimple_create_pin(cv netName layerName bbox termDir)
    let( (net term fig pin)
        net  = dbFindNetByName(cv netName)
        unless(net  net  = dbCreateNet(cv netName))

        term = dbFindTermByName(cv netName)
        unless(term term = dbCreateTerm(net netName termDir))

        fig  = dbCreateRect(cv layerName bbox)
        pin  = dbCreatePin(net fig netName)

        dbCreateLabel(cv layerName car(bbox) netName "centerCenter" "R0" "roman" 0.5)
        pin
    )
)

; ============================================================
; ENTRY POINT
; ============================================================
build_pixelated_simple()
exit(0)
