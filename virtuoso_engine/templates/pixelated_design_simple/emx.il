; ============================================================
; AUTO-GENERATED PIXELATED DESIGN SIMPLE — EMX SCRIPT
; Do not edit by hand.
; Generated by VirtuosoPixelEngine from
;   templates/pixelated_design_simple/emx.il
;
; Mode: pixelated_design_simple
;
; This script:
;   1. Exports the pixel-grid layout cell from Virtuoso to GDSII.
;   2. Runs EMX electromagnetic extraction with all layout ports:
;        PIX_IN   — left feedline input port
;        PIX_OUT  — right feedline output port
;        IND_0, IND_1, ...  — central ports for inductor pixels (row-first)
;        SW_0,  SW_1,  ...  — central ports for switch pixels   (row-first)
;
; Spectre simulation is NOT called here.
; Python reads the resulting .snp file, generates per-state Spectre netlists,
; and runs Spectre as a subprocess (see spectre_runner.py).
; ============================================================

procedure( run_pixelated_emx()
    let( (libName cellName dest_folder
          gds_file strmout_log strmout_cmd sys_status
          proc_file s_param_pattern log_file emx_cmd)

        ; --- Configuration (filled in by Python engine) ---
        libName     = "${LIB_NAME}"
        cellName    = "${CELL_NAME}"
        dest_folder = "${DEST_FOLDER}"

        unless( isDir(dest_folder) createDir(dest_folder) )

        printf("--- STARTING PIXELATED DESIGN SIMPLE EMX FLOW ---\n")
        printf("    Cell:   %s/%s\n" libName cellName)
        printf("    Output: %s\n"   dest_folder)

        ; ============================================================
        ; 1. EXPORT GDSII FROM VIRTUOSO
        ; ============================================================
        printf(">> Exporting GDSII from Virtuoso...\n")
        gds_file    = strcat(dest_folder "/" cellName ".gds")
        strmout_log = strcat(dest_folder "/strmout.log")

        strmout_cmd = sprintf(nil
            "strmout -library %s -topCell %s -view layout -strmFile %s -logFile %s -pinAttNum 1"
            libName cellName gds_file strmout_log)

        printf("Executing: %s\n" strmout_cmd)
        sys_status = system(strmout_cmd)

        if( sys_status != 0 || !isFile(gds_file) then
            error("GDS export failed! Check %s for details." strmout_log)
        )
        printf(">> GDS Export Complete: %s\n" gds_file)

        ; ============================================================
        ; 2. RUN EMX ELECTROMAGNETIC EXTRACTION
        ;
        ; Port flags and total port count are substituted by Python engine:
        ;   ${EMX_PORT_FLAGS}  — e.g. "-p PIX_IN -p PIX_OUT -p IND_0 -p SW_0"
        ;   ${TOTAL_PORTS}     — total number of ports (2 + num_ind + num_sw)
        ;
        ; No --device-cells-file: the simplified pixel layout has no sub-cell devices.
        ; --include-port-order writes "! 1 PIX_IN / ! 2 PIX_OUT ..." to the .snp header
        ; so that Python can parse the port order after EMX completes.
        ; ============================================================
        printf(">> Running EMX Extraction (%d ports)...\n" ${TOTAL_PORTS})
        proc_file       = "${PROC_FILE}"
        s_param_pattern = strcat(dest_folder "/" cellName ".s%dp")
        log_file        = strcat(dest_folder "/" cellName "_emx.log")

        emx_cmd = sprintf(nil
            "cd %s && ${EMX_BINARY} %s %s %s --sweep ${EMX_FREQ_START} ${EMX_FREQ_STOP} --sweep-stepsize ${EMX_FREQ_STEP} ${EMX_PORT_FLAGS} --quasistatic -e 2.0 -t 2.0 -v 0.5 --3d=-* -l 0 --message-file %s --log-time-level=0 --parallel ${EMX_PARALLEL} --simultaneous-frequencies=0 --recommended-memory --format touchstone2 -s %s --include-port-order --cadence-pins=1"
            dest_folder gds_file cellName proc_file log_file s_param_pattern)

        printf("Executing: %s\n" emx_cmd)
        sys_status = system(emx_cmd)

        if( sys_status != 0 then
            error("EMX extraction failed! Check %s for details." log_file)
        )
        printf(">> EMX Complete. Results saved in %s\n" dest_folder)
        printf("--- PIXELATED DESIGN SIMPLE EMX FLOW COMPLETE ---\n")
    )
)

; ============================================================
; ENTRY POINT
; ============================================================
run_pixelated_emx()
exit(0)
