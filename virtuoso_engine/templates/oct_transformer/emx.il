; ============================================================
; AUTO-GENERATED OCTAGON TRANSFORMER — EMX SCRIPT
; Generated by VirtuosoPixelEngine
;
; This script:
;   1. Exports the transformer layout to GDS
;   2. Runs EMX on the GDS
;   3. Produces a 4-port Touchstone file: cellName.s4p
; ============================================================

procedure( run_oct_transformer_emx()
    let( (libName cellName dest_folder
          gds_file strmout_log strmout_cmd sys_status
          proc_file s_param_pattern s4p_file log_file emx_cmd)

        ; --- Configuration filled in by Python engine ---
        libName     = "${LIB_NAME}"
        cellName    = "${CELL_NAME}"
        dest_folder = "${DEST_FOLDER}"

        unless( isDir(dest_folder)
            createDir(dest_folder)
        )

        printf("--- STARTING OCTAGON TRANSFORMER EMX FLOW ---\n")
        printf("    Cell:   %s/%s\n" libName cellName)
        printf("    Output: %s\n" dest_folder)

        ; ============================================================
        ; 1. EXPORT GDSII FROM VIRTUOSO
        ; ============================================================
        printf(">> Exporting GDSII from Virtuoso...\n")

        gds_file    = strcat(dest_folder "/" cellName ".gds")
        strmout_log = strcat(dest_folder "/strmout.log")

        strmout_cmd = sprintf(nil
            "strmout -library %s -topCell %s -view layout -strmFile %s -logFile %s -pinAttNum 1"
            libName cellName gds_file strmout_log
        )

        printf("Executing: %s\n" strmout_cmd)
        sys_status = system(strmout_cmd)

        if( sys_status != 0 || !isFile(gds_file) then
            error("GDS export failed! Check %s for details." strmout_log)
        )

        printf(">> GDS Export Complete: %s\n" gds_file)

        ; ============================================================
        ; 2. RUN EMX ELECTROMAGNETIC EXTRACTION
        ; ============================================================
        printf(">> Running EMX Extraction for octagonal transformer...\n")

        proc_file       = "${PROC_FILE}"
        s_param_pattern = strcat(dest_folder "/" cellName "${S_PARAM_SUFFIX}.s%dp")
        s4p_file        = strcat(dest_folder "/" cellName "${S_PARAM_SUFFIX}.s4p")
        log_file        = strcat(dest_folder "/" cellName "_emx.log")

        ; IMPORTANT:
        ; For this transformer layout, use GUI-style mapped ports:
        ;   P000=P1, P001=P2, P002=P3, P003=P4
        ; and use GND as the excluded/reference port:
        ;   -p P004=GND -x P004
        ;
        ; Do NOT use:
        ;   -p P1 -p P2 -p P3 -p P4 -g
        ;
        ; because that did not generate the .s4p correctly for your layout.

        emx_cmd = sprintf(nil
            "cd %s && ${EMX_BINARY} %s %s %s -e ${EMX_EDGE_MESH} -t ${EMX_THICKNESS} -v ${EMX_VIA_MERGE} --3d=${EMX_3D_METALS} -p P000=P1 -p P001=P2 -p P002=P3 -p P003=P4 -p P004=GND -x P004 --sweep ${EMX_FREQ_START} ${EMX_FREQ_STOP} --sweep-stepsize ${EMX_FREQ_STEP} --verbose=3 --print-command-line --log-time-level=0 --extended-warnings --message-file %s -l 0 --cadence-pins=1 --quasistatic --dump-connectivity --parallel=${EMX_PARALLEL} --simultaneous-frequencies=0 --recommended-memory --format touchstone2 -s %s --include-port-order"
            dest_folder gds_file cellName proc_file log_file s_param_pattern
        )

        printf("Executing: %s\n" emx_cmd)
        sys_status = system(emx_cmd)

        if( sys_status != 0 then
            error("EMX extraction failed! Check %s for details." log_file)
        )

        if( !isFile(s4p_file) then
            error("EMX finished but .s4p was not generated. Expected: %s. Check %s." s4p_file log_file)
        )

        printf(">> EMX Complete. Results saved in %s\n" dest_folder)
        printf(">> Expected result: %s\n" s4p_file)
        printf("--- OCTAGON TRANSFORMER EMX FLOW COMPLETE ---\n")
    )
)

; ============================================================
; ENTRY POINT
; ============================================================
run_oct_transformer_emx()
