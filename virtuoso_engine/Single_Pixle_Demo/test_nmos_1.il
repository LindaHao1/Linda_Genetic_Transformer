procedure( build_rf_pixel_auto()
let( (cv libName layoutName pdkLib nmosCell mimCell
      nmos_inst mim_inst drain_box mim_plus_box mim_minus_box mim_bulk_box
      x_center y_bottom target_point
      constraint_group_id viaOptions stack_result
      dx dy final_loc total_c mim_l mim_w
      pixel_size pixel_y_min pixel_center_y pixel_box
      keepout_box gnd_layer pixel_layer g_via_size
      gate_box bulk_box bulk_label_box via_region keepout_expanded)

; ============================================================
; 1. USER CONFIGURATION
; ============================================================
libName     = "mingTest"
layoutName  = "auto_layout_pixel_1"
pdkLib      = "tsmcN65"
nmosCell    = "nmos_rf"
mimCell     = "mimcap_um_rf"
total_c = "1p"
mim_l = "10u"
mim_w = "10u"
pixel_size  = 30.0
gnd_layer   = "M4"
pixel_layer = "M9"
g_via_size  = 3.8

; ============================================================
; 2. INITIALIZATION
; ============================================================
cv = dbOpenCellViewByType(libName layoutName "layout" "maskLayout" "w")
printf("--- Generating RF Pixel Structure ---\n")

; Place NMOS
nmos_master = dbOpenCellViewByType(pdkLib nmosCell "layout")
if( !nmos_master then error("NMOS Master not found"))
nmos_inst = dbCreateParamInst(cv nmos_master "M0" list(0.0 0.0) "R0" 1
    list(list("wr" "string" "3u") list("lr" "string" "80n") list("nr" "string" "4")))

; ============================================================
; 3. DRAIN EXTENSION & MAIN VIA STACK (M2-M8)
; ============================================================
drain_box = get_pin_boundary(nmos_inst "D")
if( drain_box then
    x_center = (xCoord(lowerLeft(drain_box)) + xCoord(upperRight(drain_box))) / 2.0
    y_bottom = yCoord(lowerLeft(drain_box))
    target_point = list(x_center (y_bottom - 2.0))

    dbCreatePath(cv "M2" list(list(x_center y_bottom) target_point) 0.5)

    ; Setup Via Options
    constraint_group_id = cstFindConstraintGroupIn(techGetTechFile(cv) "virtuosoDefaultSetup")
    viaOptions = viaGetViaOptions(constraint_group_id)
    viaOptions~>createInRoute = nil

    ; --- Generate Via Stack ---
    let( (vx vy half_size p1 p2 p3 p4 area_polygon)
        vx = xCoord(target_point)
        vy = yCoord(target_point)
        half_size = g_via_size / 2.0
        p1 = list(vx - half_size vy - 2 * half_size)
        p2 = list(vx + half_size vy - 2 * half_size)
        p3 = list(vx + half_size vy)
        p4 = list(vx - half_size vy)
        area_polygon = list(p1 p2 p3 p4)
        keepout_box = list(p1 p3)

        printf(" Building Drain Via Stack (M2-M8)...\n")
        dbCreatePolygon(cv "M2" area_polygon)
        dbCreatePolygon(cv "M8" area_polygon)
        viaGenerateViasInArea(cv area_polygon viaOptions ?topAndBottomLayers list("M2" "M8"))
    )

    ; ============================================================
    ; 3.5 NEW: GATE & BULK CONNECTIONS
    ; ============================================================

    ; --- A. Gate Extension ---
    gate_box = get_pin_boundary(nmos_inst "G")
    if( gate_box then
        let( (g_cx g_top pin_bbox)
            ; 1. Find the Center-X and Top-Y of the gate pin
            g_cx  = (xCoord(lowerLeft(gate_box)) + xCoord(upperRight(gate_box))) / 2.0
            g_top = yCoord(upperRight(gate_box))

            ; 2. Draw M3 Path extending UPWARDS from the top edge
            dbCreatePath(cv "M3" list(list(g_cx g_top) list(g_cx g_top + 1.0)) 0.5)

            ;; ================= NEW: PIN CREATION (GATE) =================
            ;; The path is 0.5 wide. Snapping a 0.5 x 0.2 pin to the top edge.
            pin_bbox = list(list(g_cx - 0.25 g_top + 0.8) list(g_cx + 0.25 g_top + 1.0))
            create_edge_pin(cv "GATE" list("M3" "pin") pin_bbox "input")
            ;; ============================================================

            printf(" Gate extended from upper side and pin added.\n")
        )
    )

    ; --- B. Bulk Connection (Using Helper Function) ---
    printf(" Finding M1 Bulk Boundaries...\n")
    bulk_label_box = get_pin_boundary(nmos_inst "B")

    if( bulk_label_box then
        printf(" M1 Bulk Boundary Identified: %L\n" bulk_label_box)
        let( (b_left b_bot b_top patch_width patch_poly)
             b_left = xCoord(lowerLeft(bulk_label_box)) + 0.1
             b_bot  = yCoord(lowerLeft(bulk_label_box))
             b_top  = yCoord(upperRight(bulk_label_box))
             patch_width = 0.6

             patch_poly = list(
                 list(b_left b_bot)
                 list(b_left + patch_width b_bot)
                 list(b_left + patch_width b_top)
                 list(b_left b_top)
             )

            via_region = list(
                 list(b_left + 0.15  b_bot)
                 list(b_left + 0.15 + 0.5 b_bot)
                 list(b_left + 0.15 + 0.5 b_top)
                 list(b_left + 0.15 b_top)
             )

             printf(" Connecting Bulk Patch...\n")
             dbCreatePolygon(cv "M1" patch_poly)
             dbCreatePolygon(cv "M4" patch_poly)
             viaGenerateViasInArea(cv via_region viaOptions ?topAndBottomLayers list("M1" "M4"))
        )
    else
        warn("No M1 shapes found in NMOS instance.")
    )

    ; ============================================================
    ; 4. PLACE MIM CAPACITOR
    ; ============================================================
    printf(" Placing MIM Capacitor...\n")
    mim_master = dbOpenCellViewByType(pdkLib mimCell "layout")
    if( mim_master then
        mim_inst = dbCreateParamInst(cv mim_master "C0" list(0.0 0.0) "R90" 1
            list(list("lt" "string" mim_l) list("wt" "string" mim_w)))

        mim_plus_box = get_pin_boundary(mim_inst "PLUS")
        if( mim_plus_box then
            let( (pin_cx pin_bottom_y)
                pin_cx = (xCoord(lowerLeft(mim_plus_box)) + xCoord(upperRight(mim_plus_box))) / 2.0
                pin_bottom_y = yCoord(lowerLeft(mim_plus_box))
                dx = xCoord(target_point) - pin_cx
                dy = yCoord(target_point) - pin_bottom_y
                mim_inst~>xy = list(dx dy)
                mim_plus_box = get_pin_boundary(mim_inst "PLUS")
                mim_minus_box = get_pin_boundary(mim_inst "MINUS")
				mim_bulk_box = get_pin_boundary(mim_inst "BULK")
            )
        )

    )

    ; ============================================================
    ; 5. MINUS SIDE VIA (M8-M9)
    ; ============================================================
    if( mim_minus_box then
        let( (mx my m_half_width m_poly)
            mx = (xCoord(lowerLeft(mim_minus_box)) + xCoord(upperRight(mim_minus_box))) / 2.0
            my = yCoord(upperRight(mim_minus_box))
            m_half_width = 1.0
            m_poly = list(
                list(mx - m_half_width my)
                list(mx + m_half_width my)
                list(mx + m_half_width my + 2 * m_half_width)
                list(mx - m_half_width my + 2 * m_half_width)
            )
            dbCreatePolygon(cv "M8" m_poly)
            dbCreatePolygon(cv "M9" m_poly)
            viaGenerateViasInArea(cv m_poly viaOptions ?topAndBottomLayers list("M8" "M9"))
        )
    )

	if( mim_bulk_box then
		let(
		(x_start y_start w_p h_p m_half_width m_poly)
			x_start = xCoord(lowerLeft(mim_bulk_box))
			y_start = yCoord(lowerLeft(mim_bulk_box))
			w_p = 1.0
			h_p = 2.0
			printf("mim bulk box at %L \n" mim_bulk_box)
			m_poly = list(
				list(x_start - w_p y_start)
				list(x_start y_start)
				list(x_start y_start + h_p)
				list(x_start - w_p y_start + h_p)
			)
			dbCreatePolygon(cv "M5" m_poly)
            dbCreatePolygon(cv "M4" m_poly)
            viaGenerateViasInArea(cv m_poly viaOptions ?topAndBottomLayers list("M4" "M5"))

		)
	)

    ; ============================================================
    ; 6. DRAW PIXEL & SHIELD
    ; ============================================================
    pixel_center_y = yCoord(target_point) - g_via_size + pixel_size/2.0 - 2.0
    pixel_box = list(
        list(xCoord(target_point) - pixel_size/2.0 pixel_center_y - pixel_size/2.0)
        list(xCoord(target_point) + pixel_size/2.0 pixel_center_y + pixel_size/2.0)
    )
    dbCreateRect(cv pixel_layer pixel_box)

    let( (gnd_fig keepout_rect spacing)
        spacing = 1.0
        if( keepout_box then
            keepout_expanded = list(
                list(xCoord(lowerLeft(keepout_box)) - spacing yCoord(lowerLeft(keepout_box)) - spacing)
                list(xCoord(upperRight(keepout_box)) + spacing yCoord(upperRight(keepout_box)) + spacing)
            )
            gnd_fig = dbCreateRect(cv gnd_layer pixel_box)
            keepout_rect = dbCreateRect(cv gnd_layer keepout_expanded)
            dbLayerAndNot(cv gnd_layer list(gnd_fig) list(keepout_rect))
            dbDeleteObject(gnd_fig)
            dbDeleteObject(keepout_rect)
        )
    )

    ;; ================= NEW: PIN CREATION (PIXEL & GND) =================
    let( (px_min py_min px_max py_max p_cen_x p_bbox g_bbox)
        px_min = xCoord(lowerLeft(pixel_box))
        py_min = yCoord(lowerLeft(pixel_box))
        px_max = xCoord(upperRight(pixel_box))
        py_max = yCoord(upperRight(pixel_box))
        p_cen_x = (px_min + px_max) / 2.0

        ; 1. Pixel Pin (M9) - Snapped to Top-Center edge
        ; Creating a 1.0 x 0.5 rectangle
        p_bbox = list(list(p_cen_x - 0.5 py_max - 0.5) list(p_cen_x + 0.5 py_max))
        create_edge_pin(cv "PIX_OUT" list(pixel_layer "pin") p_bbox "output")

        ; 2. GND Pin (M4) - Snapped to Top-Right edge (to avoid bottom-center keepout)
        ; Creating a 1.0 x 0.5 rectangle
        g_bbox = list(list(px_max - 1.0 py_max - 0.5) list(px_max py_max))
        create_edge_pin(cv "VSS" list(gnd_layer "pin") g_bbox "inputOutput")
    )
    ;; ===================================================================

else
    warn("Drain Pin D not found on NMOS")
)

dbSave(cv)
dbClose(cv)
printf("--- Layout Complete ---\n")
)
)

; ============================================================
; HELPER FUNCTIONS
; ============================================================

;; NEW: Helper function to generate Cadence layout pins
procedure( create_edge_pin(cv netName layerName bbox termDir)
    let( (net term fig pin)
        ; Check if net/term exist, otherwise create them
        net = dbFindNetByName(cv netName)
        unless(net net = dbCreateNet(cv netName))

        term = dbFindTermByName(cv netName)
        unless(term term = dbCreateTerm(net netName termDir))

        ; Create physical shape and bind to pin
        fig = dbCreateRect(cv layerName bbox)
        pin = dbCreatePin(net fig netName)

        ; Optional: Drop a label for layout readability
        dbCreateLabel(cv layerName car(bbox) netName "centerCenter" "R0" "roman" 0.5)
        pin
    )
)

; Original Pin Helper
procedure( get_pin_boundary( inst pinName )
    let( (master term pin fig rawBBox topBBox)
        master = inst~>master
        term = dbFindTermByName(master pinName)
        if( term then
            pin = car(term~>pins)
            fig = car(pin~>figs)
            rawBBox = fig~>bBox
            topBBox = dbTransformBBox(rawBBox inst~>transform)
            printf("Found pin bounds for %s: %L\n" pinName topBBox)
            topBBox
        else
            nil
        )
    )
)

procedure( get_box_from_list( overlap_obj target_layer )
    let( (final_bbox sub_bbox obj_layer bbox_raw)
        final_bbox = nil

        ; CASE 1: It is a LIST (Recursive Step)
        if( listp(overlap_obj) then
            foreach( item overlap_obj
                sub_bbox = get_box_from_list(item target_layer)

                if( sub_bbox then
                    if( final_bbox == nil then
                        final_bbox = sub_bbox
                    else
                        final_bbox = list(
                            list(min(xCoord(lowerLeft(final_bbox)) xCoord(lowerLeft(sub_bbox)))
                                 min(yCoord(lowerLeft(final_bbox)) yCoord(lowerLeft(sub_bbox))))
                            list(max(xCoord(upperRight(final_bbox)) xCoord(upperRight(sub_bbox)))
                                 max(yCoord(upperRight(final_bbox)) yCoord(upperRight(sub_bbox))))
                        )
                    )
                )
            )
            final_bbox

        ; CASE 2: It is a DATABASE OBJECT (Base Case)
        else
            obj_layer = overlap_obj~>layerName
            bbox_raw = overlap_obj~>bBox

            if( (obj_layer == target_layer && bbox_raw) then
                bbox_raw
            else
                nil
            )
        )
    )
)

procedure( find_layer_boundaries_nmos( cv inst layer purpose )
    let( (overlap_list raw_bbox final_bbox)

        printf("Scanning for %s shapes in instance %s...\n" layer inst~>name)

        overlap_list = dbGetTrueOverlaps(cv inst~>bBox list(layer purpose) 32)
        printf("Inst bbox for %s is %L \n" inst~>name inst~>bBox)
        raw_bbox = get_box_from_list(overlap_list layer)

        if( raw_bbox then
            final_bbox = dbTransformBBox(raw_bbox inst~>transform)
            printf("Found bounds: %L\n" final_bbox)
            final_bbox
        else
            warn("No shapes found on layer %s inside instance %s" layer inst~>name)
            nil
        )
    )
)
